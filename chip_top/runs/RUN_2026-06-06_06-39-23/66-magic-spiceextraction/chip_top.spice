* NGSPICE file created from chip_top.ext - technology: sky130A

* Black-box entry subcircuit for sky130_fd_sc_hd__decap_3 abstract view
.subckt sky130_fd_sc_hd__decap_3 VGND VNB VPB VPWR
.ends

* Black-box entry subcircuit for sky130_fd_sc_hd__fill_2 abstract view
.subckt sky130_fd_sc_hd__fill_2 VGND VNB VPB VPWR
.ends

* Black-box entry subcircuit for sky130_fd_sc_hd__nand2_1 abstract view
.subckt sky130_fd_sc_hd__nand2_1 A B VGND VNB VPB VPWR Y
.ends

* Black-box entry subcircuit for sky130_fd_sc_hd__dfrtp_4 abstract view
.subckt sky130_fd_sc_hd__dfrtp_4 CLK D RESET_B VGND VNB VPB VPWR Q
.ends

* Black-box entry subcircuit for sky130_fd_sc_hd__mux2_1 abstract view
.subckt sky130_fd_sc_hd__mux2_1 A0 A1 S VGND VNB VPB VPWR X
.ends

* Black-box entry subcircuit for sky130_fd_sc_hd__dfrtp_1 abstract view
.subckt sky130_fd_sc_hd__dfrtp_1 CLK D RESET_B VGND VNB VPB VPWR Q
.ends

* Black-box entry subcircuit for sky130_fd_sc_hd__inv_2 abstract view
.subckt sky130_fd_sc_hd__inv_2 A VGND VNB VPB VPWR Y
.ends

* Black-box entry subcircuit for sky130_fd_sc_hd__fill_1 abstract view
.subckt sky130_fd_sc_hd__fill_1 VGND VNB VPB VPWR
.ends

* Black-box entry subcircuit for sky130_fd_sc_hd__tapvpwrvgnd_1 abstract view
.subckt sky130_fd_sc_hd__tapvpwrvgnd_1 VGND VPWR
.ends

* Black-box entry subcircuit for sky130_fd_sc_hd__dlygate4sd1_1 abstract view
.subckt sky130_fd_sc_hd__dlygate4sd1_1 A VGND VNB VPB VPWR X
.ends

* Black-box entry subcircuit for sky130_fd_sc_hd__xnor2_1 abstract view
.subckt sky130_fd_sc_hd__xnor2_1 A B VGND VNB VPB VPWR Y
.ends

* Black-box entry subcircuit for sky130_fd_sc_hd__nor2_1 abstract view
.subckt sky130_fd_sc_hd__nor2_1 A B VGND VNB VPB VPWR Y
.ends

* Black-box entry subcircuit for sky130_fd_sc_hd__o211a_1 abstract view
.subckt sky130_fd_sc_hd__o211a_1 A1 A2 B1 C1 VGND VNB VPB VPWR X
.ends

* Black-box entry subcircuit for sky130_fd_sc_hd__a21oi_1 abstract view
.subckt sky130_fd_sc_hd__a21oi_1 A1 A2 B1 VGND VNB VPB VPWR Y
.ends

* Black-box entry subcircuit for sky130_fd_sc_hd__xnor2_2 abstract view
.subckt sky130_fd_sc_hd__xnor2_2 A B VGND VNB VPB VPWR Y
.ends

* Black-box entry subcircuit for sky130_fd_sc_hd__dlygate4sd3_1 abstract view
.subckt sky130_fd_sc_hd__dlygate4sd3_1 A VGND VNB VPB VPWR X
.ends

* Black-box entry subcircuit for sky130_fd_sc_hd__a211oi_2 abstract view
.subckt sky130_fd_sc_hd__a211oi_2 A1 A2 B1 C1 VGND VNB VPB VPWR Y
.ends

* Black-box entry subcircuit for sky130_fd_sc_hd__and3_1 abstract view
.subckt sky130_fd_sc_hd__and3_1 A B C VGND VNB VPB VPWR X
.ends

* Black-box entry subcircuit for sky130_fd_sc_hd__clkbuf_8 abstract view
.subckt sky130_fd_sc_hd__clkbuf_8 A VGND VNB VPB VPWR X
.ends

* Black-box entry subcircuit for sky130_fd_sc_hd__and2b_1 abstract view
.subckt sky130_fd_sc_hd__and2b_1 A_N B VGND VNB VPB VPWR X
.ends

* Black-box entry subcircuit for sky130_fd_sc_hd__o21a_1 abstract view
.subckt sky130_fd_sc_hd__o21a_1 A1 A2 B1 VGND VNB VPB VPWR X
.ends

* Black-box entry subcircuit for sky130_fd_sc_hd__o32ai_1 abstract view
.subckt sky130_fd_sc_hd__o32ai_1 A1 A2 A3 B1 B2 VGND VNB VPB VPWR Y
.ends

* Black-box entry subcircuit for sky130_fd_sc_hd__and3b_1 abstract view
.subckt sky130_fd_sc_hd__and3b_1 A_N B C VGND VNB VPB VPWR X
.ends

* Black-box entry subcircuit for sky130_fd_sc_hd__nand2b_1 abstract view
.subckt sky130_fd_sc_hd__nand2b_1 A_N B VGND VNB VPB VPWR Y
.ends

* Black-box entry subcircuit for sky130_fd_sc_hd__and2_1 abstract view
.subckt sky130_fd_sc_hd__and2_1 A B VGND VNB VPB VPWR X
.ends

* Black-box entry subcircuit for sky130_fd_sc_hd__a22o_1 abstract view
.subckt sky130_fd_sc_hd__a22o_1 A1 A2 B1 B2 VGND VNB VPB VPWR X
.ends

* Black-box entry subcircuit for sky130_fd_sc_hd__nand3_1 abstract view
.subckt sky130_fd_sc_hd__nand3_1 A B C VGND VNB VPB VPWR Y
.ends

* Black-box entry subcircuit for sky130_fd_sc_hd__o21ai_1 abstract view
.subckt sky130_fd_sc_hd__o21ai_1 A1 A2 B1 VGND VNB VPB VPWR Y
.ends

* Black-box entry subcircuit for sky130_fd_sc_hd__a21o_1 abstract view
.subckt sky130_fd_sc_hd__a21o_1 A1 A2 B1 VGND VNB VPB VPWR X
.ends

* Black-box entry subcircuit for sky130_fd_sc_hd__diode_2 abstract view
.subckt sky130_fd_sc_hd__diode_2 DIODE VGND VNB VPB VPWR
.ends

* Black-box entry subcircuit for sky130_fd_sc_hd__a31o_1 abstract view
.subckt sky130_fd_sc_hd__a31o_1 A1 A2 A3 B1 VGND VNB VPB VPWR X
.ends

* Black-box entry subcircuit for sky130_fd_sc_hd__buf_1 abstract view
.subckt sky130_fd_sc_hd__buf_1 A VGND VNB VPB VPWR X
.ends

* Black-box entry subcircuit for sky130_fd_sc_hd__or3b_4 abstract view
.subckt sky130_fd_sc_hd__or3b_4 A B C_N VGND VNB VPB VPWR X
.ends

* Black-box entry subcircuit for sky130_fd_sc_hd__a22oi_1 abstract view
.subckt sky130_fd_sc_hd__a22oi_1 A1 A2 B1 B2 VGND VNB VPB VPWR Y
.ends

* Black-box entry subcircuit for sky130_fd_sc_hd__or4_4 abstract view
.subckt sky130_fd_sc_hd__or4_4 A B C D VGND VNB VPB VPWR X
.ends

* Black-box entry subcircuit for sky130_fd_sc_hd__a221o_1 abstract view
.subckt sky130_fd_sc_hd__a221o_1 A1 A2 B1 B2 C1 VGND VNB VPB VPWR X
.ends

* Black-box entry subcircuit for sky130_fd_sc_hd__o22a_1 abstract view
.subckt sky130_fd_sc_hd__o22a_1 A1 A2 B1 B2 VGND VNB VPB VPWR X
.ends

* Black-box entry subcircuit for sky130_fd_sc_hd__o311a_1 abstract view
.subckt sky130_fd_sc_hd__o311a_1 A1 A2 A3 B1 C1 VGND VNB VPB VPWR X
.ends

* Black-box entry subcircuit for sky130_fd_sc_hd__xor2_1 abstract view
.subckt sky130_fd_sc_hd__xor2_1 A B VGND VNB VPB VPWR X
.ends

* Black-box entry subcircuit for sky130_fd_sc_hd__a2bb2o_1 abstract view
.subckt sky130_fd_sc_hd__a2bb2o_1 A1_N A2_N B1 B2 VGND VNB VPB VPWR X
.ends

* Black-box entry subcircuit for sky130_fd_sc_hd__o32a_1 abstract view
.subckt sky130_fd_sc_hd__o32a_1 A1 A2 A3 B1 B2 VGND VNB VPB VPWR X
.ends

* Black-box entry subcircuit for sky130_fd_sc_hd__nor4b_2 abstract view
.subckt sky130_fd_sc_hd__nor4b_2 A B C D_N VGND VNB VPB VPWR Y
.ends

* Black-box entry subcircuit for sky130_fd_sc_hd__o31a_1 abstract view
.subckt sky130_fd_sc_hd__o31a_1 A1 A2 A3 B1 VGND VNB VPB VPWR X
.ends

* Black-box entry subcircuit for sky130_fd_sc_hd__o21ba_1 abstract view
.subckt sky130_fd_sc_hd__o21ba_1 A1 A2 B1_N VGND VNB VPB VPWR X
.ends

* Black-box entry subcircuit for sky130_fd_sc_hd__or4_1 abstract view
.subckt sky130_fd_sc_hd__or4_1 A B C D VGND VNB VPB VPWR X
.ends

* Black-box entry subcircuit for sky130_fd_sc_hd__or2_1 abstract view
.subckt sky130_fd_sc_hd__or2_1 A B VGND VNB VPB VPWR X
.ends

* Black-box entry subcircuit for sky130_fd_sc_hd__or3_1 abstract view
.subckt sky130_fd_sc_hd__or3_1 A B C VGND VNB VPB VPWR X
.ends

* Black-box entry subcircuit for sky130_fd_sc_hd__nor2_8 abstract view
.subckt sky130_fd_sc_hd__nor2_8 A B VGND VNB VPB VPWR Y
.ends

* Black-box entry subcircuit for sky130_fd_sc_hd__or4b_4 abstract view
.subckt sky130_fd_sc_hd__or4b_4 A B C D_N VGND VNB VPB VPWR X
.ends

* Black-box entry subcircuit for sky130_fd_sc_hd__or3b_1 abstract view
.subckt sky130_fd_sc_hd__or3b_1 A B C_N VGND VNB VPB VPWR X
.ends

* Black-box entry subcircuit for sky130_fd_sc_hd__o221a_4 abstract view
.subckt sky130_fd_sc_hd__o221a_4 A1 A2 B1 B2 C1 VGND VNB VPB VPWR X
.ends

* Black-box entry subcircuit for sky130_fd_sc_hd__xnor2_4 abstract view
.subckt sky130_fd_sc_hd__xnor2_4 A B VGND VNB VPB VPWR Y
.ends

* Black-box entry subcircuit for sky130_fd_sc_hd__and4b_1 abstract view
.subckt sky130_fd_sc_hd__and4b_1 A_N B C D VGND VNB VPB VPWR X
.ends

* Black-box entry subcircuit for sky130_fd_sc_hd__a211oi_1 abstract view
.subckt sky130_fd_sc_hd__a211oi_1 A1 A2 B1 C1 VGND VNB VPB VPWR Y
.ends

* Black-box entry subcircuit for sky130_fd_sc_hd__dfstp_1 abstract view
.subckt sky130_fd_sc_hd__dfstp_1 CLK D SET_B VGND VNB VPB VPWR Q
.ends

* Black-box entry subcircuit for sky130_fd_sc_hd__nand2_2 abstract view
.subckt sky130_fd_sc_hd__nand2_2 A B VGND VNB VPB VPWR Y
.ends

* Black-box entry subcircuit for sky130_fd_sc_hd__o311a_4 abstract view
.subckt sky130_fd_sc_hd__o311a_4 A1 A2 A3 B1 C1 VGND VNB VPB VPWR X
.ends

* Black-box entry subcircuit for sky130_fd_sc_hd__dfrtp_2 abstract view
.subckt sky130_fd_sc_hd__dfrtp_2 CLK D RESET_B VGND VNB VPB VPWR Q
.ends

* Black-box entry subcircuit for sky130_fd_sc_hd__or3_2 abstract view
.subckt sky130_fd_sc_hd__or3_2 A B C VGND VNB VPB VPWR X
.ends

* Black-box entry subcircuit for sky130_fd_sc_hd__nand2b_2 abstract view
.subckt sky130_fd_sc_hd__nand2b_2 A_N B VGND VNB VPB VPWR Y
.ends

* Black-box entry subcircuit for sky130_fd_sc_hd__and4_2 abstract view
.subckt sky130_fd_sc_hd__and4_2 A B C D VGND VNB VPB VPWR X
.ends

* Black-box entry subcircuit for sky130_fd_sc_hd__nor3b_1 abstract view
.subckt sky130_fd_sc_hd__nor3b_1 A B C_N VGND VNB VPB VPWR Y
.ends

* Black-box entry subcircuit for sky130_fd_sc_hd__or2_4 abstract view
.subckt sky130_fd_sc_hd__or2_4 A B VGND VNB VPB VPWR X
.ends

* Black-box entry subcircuit for sky130_fd_sc_hd__o31ai_1 abstract view
.subckt sky130_fd_sc_hd__o31ai_1 A1 A2 A3 B1 VGND VNB VPB VPWR Y
.ends

* Black-box entry subcircuit for sky130_fd_sc_hd__o31ai_4 abstract view
.subckt sky130_fd_sc_hd__o31ai_4 A1 A2 A3 B1 VGND VNB VPB VPWR Y
.ends

* Black-box entry subcircuit for sky130_fd_sc_hd__nor2_2 abstract view
.subckt sky130_fd_sc_hd__nor2_2 A B VGND VNB VPB VPWR Y
.ends

* Black-box entry subcircuit for sky130_fd_sc_hd__inv_8 abstract view
.subckt sky130_fd_sc_hd__inv_8 A VGND VNB VPB VPWR Y
.ends

* Black-box entry subcircuit for sky130_fd_sc_hd__and4_1 abstract view
.subckt sky130_fd_sc_hd__and4_1 A B C D VGND VNB VPB VPWR X
.ends

* Black-box entry subcircuit for sky130_fd_sc_hd__a31oi_1 abstract view
.subckt sky130_fd_sc_hd__a31oi_1 A1 A2 A3 B1 VGND VNB VPB VPWR Y
.ends

* Black-box entry subcircuit for sky130_fd_sc_hd__nor2_4 abstract view
.subckt sky130_fd_sc_hd__nor2_4 A B VGND VNB VPB VPWR Y
.ends

* Black-box entry subcircuit for sky130_fd_sc_hd__inv_6 abstract view
.subckt sky130_fd_sc_hd__inv_6 A VGND VNB VPB VPWR Y
.ends

* Black-box entry subcircuit for sky130_fd_sc_hd__nand4_1 abstract view
.subckt sky130_fd_sc_hd__nand4_1 A B C D VGND VNB VPB VPWR Y
.ends

* Black-box entry subcircuit for sky130_fd_sc_hd__o21bai_1 abstract view
.subckt sky130_fd_sc_hd__o21bai_1 A1 A2 B1_N VGND VNB VPB VPWR Y
.ends

* Black-box entry subcircuit for sky130_fd_sc_hd__o22ai_1 abstract view
.subckt sky130_fd_sc_hd__o22ai_1 A1 A2 B1 B2 VGND VNB VPB VPWR Y
.ends

* Black-box entry subcircuit for sky130_fd_sc_hd__xor2_2 abstract view
.subckt sky130_fd_sc_hd__xor2_2 A B VGND VNB VPB VPWR X
.ends

* Black-box entry subcircuit for sky130_fd_sc_hd__a211o_1 abstract view
.subckt sky130_fd_sc_hd__a211o_1 A1 A2 B1 C1 VGND VNB VPB VPWR X
.ends

* Black-box entry subcircuit for sky130_fd_sc_hd__inv_12 abstract view
.subckt sky130_fd_sc_hd__inv_12 A VGND VNB VPB VPWR Y
.ends

* Black-box entry subcircuit for sky130_fd_sc_hd__or2_2 abstract view
.subckt sky130_fd_sc_hd__or2_2 A B VGND VNB VPB VPWR X
.ends

* Black-box entry subcircuit for sky130_fd_sc_hd__a21bo_2 abstract view
.subckt sky130_fd_sc_hd__a21bo_2 A1 A2 B1_N VGND VNB VPB VPWR X
.ends

* Black-box entry subcircuit for sky130_fd_sc_hd__o41a_1 abstract view
.subckt sky130_fd_sc_hd__o41a_1 A1 A2 A3 A4 B1 VGND VNB VPB VPWR X
.ends

* Black-box entry subcircuit for sky130_fd_sc_hd__o21ai_2 abstract view
.subckt sky130_fd_sc_hd__o21ai_2 A1 A2 B1 VGND VNB VPB VPWR Y
.ends

* Black-box entry subcircuit for sky130_fd_sc_hd__a32o_1 abstract view
.subckt sky130_fd_sc_hd__a32o_1 A1 A2 A3 B1 B2 VGND VNB VPB VPWR X
.ends

* Black-box entry subcircuit for sky130_fd_sc_hd__and3b_2 abstract view
.subckt sky130_fd_sc_hd__and3b_2 A_N B C VGND VNB VPB VPWR X
.ends

* Black-box entry subcircuit for sky130_fd_sc_hd__clkbuf_16 abstract view
.subckt sky130_fd_sc_hd__clkbuf_16 A VGND VNB VPB VPWR X
.ends

* Black-box entry subcircuit for sky130_fd_sc_hd__o2111a_1 abstract view
.subckt sky130_fd_sc_hd__o2111a_1 A1 A2 B1 C1 D1 VGND VNB VPB VPWR X
.ends

* Black-box entry subcircuit for sky130_fd_sc_hd__nand3b_1 abstract view
.subckt sky130_fd_sc_hd__nand3b_1 A_N B C VGND VNB VPB VPWR Y
.ends

* Black-box entry subcircuit for sky130_fd_sc_hd__clkinv_8 abstract view
.subckt sky130_fd_sc_hd__clkinv_8 A VGND VNB VPB VPWR Y
.ends

* Black-box entry subcircuit for sky130_fd_sc_hd__o2bb2a_1 abstract view
.subckt sky130_fd_sc_hd__o2bb2a_1 A1_N A2_N B1 B2 VGND VNB VPB VPWR X
.ends

* Black-box entry subcircuit for sky130_fd_sc_hd__and2_2 abstract view
.subckt sky130_fd_sc_hd__and2_2 A B VGND VNB VPB VPWR X
.ends

* Black-box entry subcircuit for sky130_fd_sc_hd__and2_4 abstract view
.subckt sky130_fd_sc_hd__and2_4 A B VGND VNB VPB VPWR X
.ends

* Black-box entry subcircuit for sky130_fd_sc_hd__inv_16 abstract view
.subckt sky130_fd_sc_hd__inv_16 A VGND VNB VPB VPWR Y
.ends

* Black-box entry subcircuit for sky130_fd_sc_hd__a21bo_1 abstract view
.subckt sky130_fd_sc_hd__a21bo_1 A1 A2 B1_N VGND VNB VPB VPWR X
.ends

* Black-box entry subcircuit for sky130_fd_sc_hd__o221a_1 abstract view
.subckt sky130_fd_sc_hd__o221a_1 A1 A2 B1 B2 C1 VGND VNB VPB VPWR X
.ends

* Black-box entry subcircuit for sky130_fd_sc_hd__a2111o_1 abstract view
.subckt sky130_fd_sc_hd__a2111o_1 A1 A2 B1 C1 D1 VGND VNB VPB VPWR X
.ends

* Black-box entry subcircuit for sky130_fd_sc_hd__nor3_1 abstract view
.subckt sky130_fd_sc_hd__nor3_1 A B C VGND VNB VPB VPWR Y
.ends

* Black-box entry subcircuit for sky130_fd_sc_hd__a21boi_1 abstract view
.subckt sky130_fd_sc_hd__a21boi_1 A1 A2 B1_N VGND VNB VPB VPWR Y
.ends

* Black-box entry subcircuit for sky130_fd_sc_hd__o311ai_1 abstract view
.subckt sky130_fd_sc_hd__o311ai_1 A1 A2 A3 B1 C1 VGND VNB VPB VPWR Y
.ends

* Black-box entry subcircuit for sky130_fd_sc_hd__o2111ai_1 abstract view
.subckt sky130_fd_sc_hd__o2111ai_1 A1 A2 B1 C1 D1 VGND VNB VPB VPWR Y
.ends

* Black-box entry subcircuit for sky130_fd_sc_hd__or4bb_1 abstract view
.subckt sky130_fd_sc_hd__or4bb_1 A B C_N D_N VGND VNB VPB VPWR X
.ends

* Black-box entry subcircuit for sky130_fd_sc_hd__clkbuf_1 abstract view
.subckt sky130_fd_sc_hd__clkbuf_1 A VGND VNB VPB VPWR X
.ends

* Black-box entry subcircuit for sky130_fd_sc_hd__or3b_2 abstract view
.subckt sky130_fd_sc_hd__or3b_2 A B C_N VGND VNB VPB VPWR X
.ends

* Black-box entry subcircuit for sky130_fd_sc_hd__o211ai_4 abstract view
.subckt sky130_fd_sc_hd__o211ai_4 A1 A2 B1 C1 VGND VNB VPB VPWR Y
.ends

* Black-box entry subcircuit for sky130_fd_sc_hd__o211a_2 abstract view
.subckt sky130_fd_sc_hd__o211a_2 A1 A2 B1 C1 VGND VNB VPB VPWR X
.ends

* Black-box entry subcircuit for sky130_fd_sc_hd__dfstp_4 abstract view
.subckt sky130_fd_sc_hd__dfstp_4 CLK D SET_B VGND VNB VPB VPWR Q
.ends

* Black-box entry subcircuit for sky130_fd_sc_hd__or4_2 abstract view
.subckt sky130_fd_sc_hd__or4_2 A B C D VGND VNB VPB VPWR X
.ends

* Black-box entry subcircuit for sky130_fd_sc_hd__and4bb_1 abstract view
.subckt sky130_fd_sc_hd__and4bb_1 A_N B_N C D VGND VNB VPB VPWR X
.ends

* Black-box entry subcircuit for sky130_fd_sc_hd__or4b_1 abstract view
.subckt sky130_fd_sc_hd__or4b_1 A B C D_N VGND VNB VPB VPWR X
.ends

* Black-box entry subcircuit for sky130_fd_sc_hd__o21bai_4 abstract view
.subckt sky130_fd_sc_hd__o21bai_4 A1 A2 B1_N VGND VNB VPB VPWR Y
.ends

* Black-box entry subcircuit for sky130_fd_sc_hd__a31oi_2 abstract view
.subckt sky130_fd_sc_hd__a31oi_2 A1 A2 A3 B1 VGND VNB VPB VPWR Y
.ends

* Black-box entry subcircuit for sky130_fd_sc_hd__o221a_2 abstract view
.subckt sky130_fd_sc_hd__o221a_2 A1 A2 B1 B2 C1 VGND VNB VPB VPWR X
.ends

* Black-box entry subcircuit for sky130_fd_sc_hd__mux2_2 abstract view
.subckt sky130_fd_sc_hd__mux2_2 A0 A1 S VGND VNB VPB VPWR X
.ends

* Black-box entry subcircuit for sky130_fd_sc_hd__a21oi_4 abstract view
.subckt sky130_fd_sc_hd__a21oi_4 A1 A2 B1 VGND VNB VPB VPWR Y
.ends

* Black-box entry subcircuit for sky130_fd_sc_hd__nand2_4 abstract view
.subckt sky130_fd_sc_hd__nand2_4 A B VGND VNB VPB VPWR Y
.ends

* Black-box entry subcircuit for sky130_fd_sc_hd__a21oi_2 abstract view
.subckt sky130_fd_sc_hd__a21oi_2 A1 A2 B1 VGND VNB VPB VPWR Y
.ends

* Black-box entry subcircuit for sky130_fd_sc_hd__o22ai_2 abstract view
.subckt sky130_fd_sc_hd__o22ai_2 A1 A2 B1 B2 VGND VNB VPB VPWR Y
.ends

* Black-box entry subcircuit for sky130_fd_sc_hd__or4b_2 abstract view
.subckt sky130_fd_sc_hd__or4b_2 A B C D_N VGND VNB VPB VPWR X
.ends

* Black-box entry subcircuit for sky130_fd_sc_hd__mux4_1 abstract view
.subckt sky130_fd_sc_hd__mux4_1 A0 A1 A2 A3 S0 S1 VGND VNB VPB VPWR X
.ends

* Black-box entry subcircuit for sky130_fd_sc_hd__nor4b_4 abstract view
.subckt sky130_fd_sc_hd__nor4b_4 A B C D_N VGND VNB VPB VPWR Y
.ends

* Black-box entry subcircuit for sky130_fd_sc_hd__and2b_2 abstract view
.subckt sky130_fd_sc_hd__and2b_2 A_N B VGND VNB VPB VPWR X
.ends

* Black-box entry subcircuit for sky130_fd_sc_hd__o211ai_1 abstract view
.subckt sky130_fd_sc_hd__o211ai_1 A1 A2 B1 C1 VGND VNB VPB VPWR Y
.ends

* Black-box entry subcircuit for sky130_fd_sc_hd__nor4_4 abstract view
.subckt sky130_fd_sc_hd__nor4_4 A B C D VGND VNB VPB VPWR Y
.ends

* Black-box entry subcircuit for sky130_fd_sc_hd__clkinv_4 abstract view
.subckt sky130_fd_sc_hd__clkinv_4 A VGND VNB VPB VPWR Y
.ends

* Black-box entry subcircuit for sky130_fd_sc_hd__a41oi_1 abstract view
.subckt sky130_fd_sc_hd__a41oi_1 A1 A2 A3 A4 B1 VGND VNB VPB VPWR Y
.ends

* Black-box entry subcircuit for sky130_fd_sc_hd__nor4_1 abstract view
.subckt sky130_fd_sc_hd__nor4_1 A B C D VGND VNB VPB VPWR Y
.ends

* Black-box entry subcircuit for sky130_fd_sc_hd__buf_2 abstract view
.subckt sky130_fd_sc_hd__buf_2 A VGND VNB VPB VPWR X
.ends

* Black-box entry subcircuit for sky130_fd_sc_hd__a21o_4 abstract view
.subckt sky130_fd_sc_hd__a21o_4 A1 A2 B1 VGND VNB VPB VPWR X
.ends

* Black-box entry subcircuit for sky130_fd_sc_hd__o2bb2a_2 abstract view
.subckt sky130_fd_sc_hd__o2bb2a_2 A1_N A2_N B1 B2 VGND VNB VPB VPWR X
.ends

* Black-box entry subcircuit for sky130_fd_sc_hd__dlymetal6s2s_1 abstract view
.subckt sky130_fd_sc_hd__dlymetal6s2s_1 A VGND VNB VPB VPWR X
.ends

* Black-box entry subcircuit for sky130_fd_sc_hd__a221oi_2 abstract view
.subckt sky130_fd_sc_hd__a221oi_2 A1 A2 B1 B2 C1 VGND VNB VPB VPWR Y
.ends

* Black-box entry subcircuit for sky130_fd_sc_hd__xor2_4 abstract view
.subckt sky130_fd_sc_hd__xor2_4 A B VGND VNB VPB VPWR X
.ends

* Black-box entry subcircuit for sky130_fd_sc_hd__a2111o_2 abstract view
.subckt sky130_fd_sc_hd__a2111o_2 A1 A2 B1 C1 D1 VGND VNB VPB VPWR X
.ends

* Black-box entry subcircuit for sky130_fd_sc_hd__buf_8 abstract view
.subckt sky130_fd_sc_hd__buf_8 A VGND VNB VPB VPWR X
.ends

* Black-box entry subcircuit for sky130_fd_sc_hd__a41o_1 abstract view
.subckt sky130_fd_sc_hd__a41o_1 A1 A2 A3 A4 B1 VGND VNB VPB VPWR X
.ends

* Black-box entry subcircuit for sky130_fd_sc_hd__a32o_2 abstract view
.subckt sky130_fd_sc_hd__a32o_2 A1 A2 A3 B1 B2 VGND VNB VPB VPWR X
.ends

* Black-box entry subcircuit for sky130_fd_sc_hd__and2b_4 abstract view
.subckt sky130_fd_sc_hd__and2b_4 A_N B VGND VNB VPB VPWR X
.ends

* Black-box entry subcircuit for sky130_fd_sc_hd__or3_4 abstract view
.subckt sky130_fd_sc_hd__or3_4 A B C VGND VNB VPB VPWR X
.ends

* Black-box entry subcircuit for sky130_fd_sc_hd__nor3_4 abstract view
.subckt sky130_fd_sc_hd__nor3_4 A B C VGND VNB VPB VPWR Y
.ends

.subckt chip_top VGND VPWR clk miso mosi rst sclk ss
XFILLER_54_247 VGND VGND VPWR VPWR sky130_fd_sc_hd__decap_3
XFILLER_54_203 VGND VGND VPWR VPWR sky130_fd_sc_hd__fill_2
XFILLER_39_222 VGND VGND VPWR VPWR sky130_fd_sc_hd__fill_2
X_2037_ _1446_ _1488_ VGND VGND VPWR VPWR _0441_ sky130_fd_sc_hd__nand2_1
X_3086_ clknet_4_6_0_clk net304 _0182_ VGND VGND VPWR VPWR acc_reg\[7\] sky130_fd_sc_hd__dfrtp_4
X_2106_ net112 net96 net88 VGND VGND VPWR VPWR _0221_ sky130_fd_sc_hd__mux2_1
X_3155_ clknet_4_0_0_clk net186 _0066_ VGND VGND VPWR VPWR state\[3\] sky130_fd_sc_hd__dfrtp_1
XFILLER_52_29 VGND VGND VPWR VPWR sky130_fd_sc_hd__fill_2
X_2939_ net2 VGND VGND VPWR VPWR _0035_ sky130_fd_sc_hd__inv_2
XFILLER_10_317 VGND VGND VPWR VPWR sky130_fd_sc_hd__decap_3
XFILLER_45_236 VGND VGND VPWR VPWR sky130_fd_sc_hd__fill_1
XFILLER_45_214 VGND VGND VPWR VPWR sky130_fd_sc_hd__fill_2
XTAP_TAPCELL_ROW_43_415 VGND VPWR sky130_fd_sc_hd__tapvpwrvgnd_1
Xrebuffer7 my_sum_sub.cm_exp\[3\] VGND VGND VPWR VPWR net12 sky130_fd_sc_hd__dlygate4sd1_1
XFILLER_5_310 VGND VGND VPWR VPWR sky130_fd_sc_hd__decap_3
XFILLER_13_166 VGND VGND VPWR VPWR sky130_fd_sc_hd__fill_2
XFILLER_54_9 VGND VGND VPWR VPWR sky130_fd_sc_hd__decap_3
XFILLER_5_332 VGND VGND VPWR VPWR sky130_fd_sc_hd__decap_3
XFILLER_5_343 VGND VGND VPWR VPWR sky130_fd_sc_hd__fill_2
XFILLER_36_225 VGND VGND VPWR VPWR sky130_fd_sc_hd__decap_3
XFILLER_36_203 VGND VGND VPWR VPWR sky130_fd_sc_hd__fill_2
XFILLER_51_228 VGND VGND VPWR VPWR sky130_fd_sc_hd__decap_3
XFILLER_44_291 VGND VGND VPWR VPWR sky130_fd_sc_hd__fill_2
X_1606_ _1144_ _1149_ VGND VGND VPWR VPWR _1150_ sky130_fd_sc_hd__xnor2_1
X_2724_ _0975_ _0999_ VGND VGND VPWR VPWR _1000_ sky130_fd_sc_hd__nor2_1
X_2655_ _0740_ _0743_ _0952_ _0953_ VGND VGND VPWR VPWR _0954_ sky130_fd_sc_hd__o211a_1
XFILLER_59_317 VGND VGND VPWR VPWR sky130_fd_sc_hd__decap_3
XTAP_TAPCELL_ROW_57_507 VGND VPWR sky130_fd_sc_hd__tapvpwrvgnd_1
X_1537_ _1069_ _1083_ net188 VGND VGND VPWR VPWR _0240_ sky130_fd_sc_hd__a21oi_1
X_2586_ _0862_ _0881_ VGND VGND VPWR VPWR _0885_ sky130_fd_sc_hd__xnor2_2
X_3069_ clknet_4_12_0_clk _0328_ _0165_ VGND VGND VPWR VPWR my_sum_sub.cm_sign sky130_fd_sc_hd__dfrtp_1
XFILLER_27_225 VGND VGND VPWR VPWR sky130_fd_sc_hd__fill_1
X_3138_ clknet_4_4_0_clk net59 _0049_ VGND VGND VPWR VPWR shift_out\[11\] sky130_fd_sc_hd__dfrtp_1
Xhold170 _0508_ VGND VGND VPWR VPWR net175 sky130_fd_sc_hd__dlygate4sd3_1
XFILLER_2_368 VGND VGND VPWR VPWR sky130_fd_sc_hd__fill_2
Xhold181 _0008_ VGND VGND VPWR VPWR net186 sky130_fd_sc_hd__dlygate4sd3_1
Xhold192 _0269_ VGND VGND VPWR VPWR net197 sky130_fd_sc_hd__dlygate4sd3_1
XFILLER_41_272 VGND VGND VPWR VPWR sky130_fd_sc_hd__decap_3
XFILLER_33_228 VGND VGND VPWR VPWR sky130_fd_sc_hd__decap_3
XFILLER_33_206 VGND VGND VPWR VPWR sky130_fd_sc_hd__decap_3
X_2440_ _0728_ _0731_ _0737_ _0725_ VGND VGND VPWR VPWR _0739_ sky130_fd_sc_hd__a211oi_2
XFILLER_56_309 VGND VGND VPWR VPWR sky130_fd_sc_hd__decap_3
X_2371_ acc_reg\[5\] _0364_ _0606_ VGND VGND VPWR VPWR _0684_ sky130_fd_sc_hd__and3_1
XFILLER_24_228 VGND VGND VPWR VPWR sky130_fd_sc_hd__decap_3
XPHY_EDGE_ROW_20_Left_83 VGND VGND VPWR VPWR sky130_fd_sc_hd__decap_3
XTAP_TAPCELL_ROW_62_543 VGND VPWR sky130_fd_sc_hd__tapvpwrvgnd_1
Xclkbuf_4_12_0_clk clknet_0_clk VGND VGND VPWR VPWR clknet_4_12_0_clk sky130_fd_sc_hd__clkbuf_8
X_2707_ my_divider.divisor_reg\[3\] net194 VGND VGND VPWR VPWR _0983_ sky130_fd_sc_hd__and2b_1
X_2569_ _0843_ _0866_ _0842_ VGND VGND VPWR VPWR _0868_ sky130_fd_sc_hd__o21a_1
X_2638_ _0910_ _0919_ _0935_ _0908_ my_sum_sub.cm_exp\[6\] VGND VGND VPWR VPWR _0937_
+ sky130_fd_sc_hd__o32ai_1
XFILLER_59_169 VGND VGND VPWR VPWR sky130_fd_sc_hd__decap_3
XFILLER_55_353 VGND VGND VPWR VPWR sky130_fd_sc_hd__decap_3
XFILLER_30_209 VGND VGND VPWR VPWR sky130_fd_sc_hd__fill_1
XFILLER_23_53 VGND VGND VPWR VPWR sky130_fd_sc_hd__decap_3
XFILLER_48_50 VGND VGND VPWR VPWR sky130_fd_sc_hd__decap_3
XFILLER_61_323 VGND VGND VPWR VPWR sky130_fd_sc_hd__decap_3
XFILLER_58_180 VGND VGND VPWR VPWR sky130_fd_sc_hd__decap_3
XFILLER_0_57 VGND VGND VPWR VPWR sky130_fd_sc_hd__decap_3
XFILLER_61_367 VGND VGND VPWR VPWR sky130_fd_sc_hd__decap_3
X_1940_ _1457_ _1420_ _1183_ VGND VGND VPWR VPWR _1484_ sky130_fd_sc_hd__and3b_1
X_1871_ _1229_ _1414_ VGND VGND VPWR VPWR _1415_ sky130_fd_sc_hd__nor2_1
XFILLER_14_261 VGND VGND VPWR VPWR sky130_fd_sc_hd__fill_2
XFILLER_14_283 VGND VGND VPWR VPWR sky130_fd_sc_hd__fill_1
XFILLER_14_294 VGND VGND VPWR VPWR sky130_fd_sc_hd__decap_3
XFILLER_50_3 VGND VGND VPWR VPWR sky130_fd_sc_hd__decap_3
X_2423_ _0721_ _0720_ VGND VGND VPWR VPWR _0722_ sky130_fd_sc_hd__nand2b_1
XFILLER_56_117 VGND VGND VPWR VPWR sky130_fd_sc_hd__decap_3
X_2354_ _0622_ _0628_ VGND VGND VPWR VPWR _0671_ sky130_fd_sc_hd__and2_1
X_2285_ net269 net247 my_sum_sub.state\[2\] VGND VGND VPWR VPWR _0316_ sky130_fd_sc_hd__mux2_1
XFILLER_60_18 VGND VGND VPWR VPWR sky130_fd_sc_hd__decap_3
XFILLER_62_109 VGND VGND VPWR VPWR sky130_fd_sc_hd__decap_3
XFILLER_47_106 VGND VGND VPWR VPWR sky130_fd_sc_hd__decap_3
XTAP_TAPCELL_ROW_38_381 VGND VPWR sky130_fd_sc_hd__tapvpwrvgnd_1
XFILLER_11_253 VGND VGND VPWR VPWR sky130_fd_sc_hd__decap_3
XFILLER_50_73 VGND VGND VPWR VPWR sky130_fd_sc_hd__decap_3
XTAP_TAPCELL_ROW_21_270 VGND VPWR sky130_fd_sc_hd__tapvpwrvgnd_1
XFILLER_7_257 VGND VGND VPWR VPWR sky130_fd_sc_hd__fill_2
XFILLER_59_60 VGND VGND VPWR VPWR sky130_fd_sc_hd__decap_3
XFILLER_38_106 VGND VGND VPWR VPWR sky130_fd_sc_hd__decap_3
X_2070_ net165 _1088_ _1090_ net53 VGND VGND VPWR VPWR _0470_ sky130_fd_sc_hd__a22o_1
XFILLER_15_6 VGND VGND VPWR VPWR sky130_fd_sc_hd__decap_3
X_2972_ net2 VGND VGND VPWR VPWR _0068_ sky130_fd_sc_hd__inv_2
X_1785_ my_mul.x2\[1\] acc_reg\[5\] VGND VGND VPWR VPWR _1329_ sky130_fd_sc_hd__nand2_1
X_1854_ _1391_ _1397_ VGND VGND VPWR VPWR _1398_ sky130_fd_sc_hd__nand2b_1
X_1923_ _1464_ _1466_ _1422_ VGND VGND VPWR VPWR _1467_ sky130_fd_sc_hd__mux2_1
X_2406_ net20 _0702_ _0703_ VGND VGND VPWR VPWR _0705_ sky130_fd_sc_hd__nand3_1
XFILLER_55_18 VGND VGND VPWR VPWR sky130_fd_sc_hd__decap_3
X_2199_ _0515_ _0516_ VGND VGND VPWR VPWR _0534_ sky130_fd_sc_hd__nor2_1
X_2337_ _0625_ _0655_ _0618_ VGND VGND VPWR VPWR _0656_ sky130_fd_sc_hd__mux2_1
X_2268_ _0593_ _0595_ _0546_ VGND VGND VPWR VPWR _0596_ sky130_fd_sc_hd__o21ai_1
XFILLER_37_161 VGND VGND VPWR VPWR sky130_fd_sc_hd__decap_3
XFILLER_52_197 VGND VGND VPWR VPWR sky130_fd_sc_hd__decap_3
XFILLER_52_164 VGND VGND VPWR VPWR sky130_fd_sc_hd__decap_3
XFILLER_52_131 VGND VGND VPWR VPWR sky130_fd_sc_hd__decap_3
XFILLER_40_315 VGND VGND VPWR VPWR sky130_fd_sc_hd__decap_3
XFILLER_40_304 VGND VGND VPWR VPWR sky130_fd_sc_hd__decap_3
XTAP_TAPCELL_ROW_35_362 VGND VPWR sky130_fd_sc_hd__tapvpwrvgnd_1
XFILLER_20_32 VGND VGND VPWR VPWR sky130_fd_sc_hd__decap_3
XFILLER_4_205 VGND VGND VPWR VPWR sky130_fd_sc_hd__decap_3
XFILLER_4_249 VGND VGND VPWR VPWR sky130_fd_sc_hd__decap_3
XPHY_EDGE_ROW_42_Left_105 VGND VGND VPWR VPWR sky130_fd_sc_hd__decap_3
Xhold41 shift_out\[2\] VGND VGND VPWR VPWR net46 sky130_fd_sc_hd__dlygate4sd3_1
Xhold63 shift_in\[8\] VGND VGND VPWR VPWR net68 sky130_fd_sc_hd__dlygate4sd3_1
XFILLER_29_74 VGND VGND VPWR VPWR sky130_fd_sc_hd__fill_1
XFILLER_29_41 VGND VGND VPWR VPWR sky130_fd_sc_hd__decap_3
Xhold52 _0233_ VGND VGND VPWR VPWR net57 sky130_fd_sc_hd__dlygate4sd3_1
Xhold74 my_divider.divisor_reg\[1\] VGND VGND VPWR VPWR net79 sky130_fd_sc_hd__dlygate4sd3_1
Xhold30 div_quotient\[6\] VGND VGND VPWR VPWR net35 sky130_fd_sc_hd__dlygate4sd3_1
XPHY_EDGE_ROW_51_Left_114 VGND VGND VPWR VPWR sky130_fd_sc_hd__decap_3
XFILLER_43_186 VGND VGND VPWR VPWR sky130_fd_sc_hd__decap_3
XFILLER_43_142 VGND VGND VPWR VPWR sky130_fd_sc_hd__fill_2
XFILLER_43_131 VGND VGND VPWR VPWR sky130_fd_sc_hd__fill_1
Xhold96 my_divider.divisor_reg\[7\] VGND VGND VPWR VPWR net101 sky130_fd_sc_hd__dlygate4sd3_1
Xhold85 _0273_ VGND VGND VPWR VPWR net90 sky130_fd_sc_hd__dlygate4sd3_1
XFILLER_16_301 VGND VGND VPWR VPWR sky130_fd_sc_hd__decap_3
XFILLER_16_312 VGND VGND VPWR VPWR sky130_fd_sc_hd__decap_3
XPHY_EDGE_ROW_60_Left_123 VGND VGND VPWR VPWR sky130_fd_sc_hd__decap_3
X_1570_ my_mul.x2\[11\] acc_reg\[11\] _1112_ VGND VGND VPWR VPWR _1114_ sky130_fd_sc_hd__a21o_1
XANTENNA_5 my_sum_sub.state\[3\] VGND VGND VPWR VPWR sky130_fd_sc_hd__diode_2
XTAP_TAPCELL_ROW_49_454 VGND VPWR sky130_fd_sc_hd__tapvpwrvgnd_1
X_2053_ _1153_ _0408_ _0454_ _1090_ VGND VGND VPWR VPWR _0455_ sky130_fd_sc_hd__a31o_1
Xrebuffer17 my_sum_sub.cm_exp\[1\] VGND VGND VPWR VPWR net22 sky130_fd_sc_hd__buf_1
XFILLER_19_161 VGND VGND VPWR VPWR sky130_fd_sc_hd__decap_3
X_2122_ _0499_ ss_s1 net173 VGND VGND VPWR VPWR _0500_ sky130_fd_sc_hd__or3b_4
X_3171_ clknet_4_3_0_clk net133 _0082_ VGND VGND VPWR VPWR my_sum_sub.done sky130_fd_sc_hd__dfrtp_1
XFILLER_34_197 VGND VGND VPWR VPWR sky130_fd_sc_hd__decap_3
XFILLER_34_164 VGND VGND VPWR VPWR sky130_fd_sc_hd__decap_3
XFILLER_34_153 VGND VGND VPWR VPWR sky130_fd_sc_hd__decap_3
XTAP_TAPCELL_ROW_32_343 VGND VPWR sky130_fd_sc_hd__tapvpwrvgnd_1
X_2955_ net5 VGND VGND VPWR VPWR _0051_ sky130_fd_sc_hd__inv_2
X_1768_ _1309_ _1311_ _1307_ VGND VGND VPWR VPWR _1312_ sky130_fd_sc_hd__a21oi_1
X_1837_ my_mul.x2\[0\] acc_reg\[3\] acc_reg\[2\] my_mul.x2\[1\] VGND VGND VPWR VPWR
+ _1381_ sky130_fd_sc_hd__a22oi_1
X_1906_ _1449_ VGND VGND VPWR VPWR _1450_ sky130_fd_sc_hd__inv_2
X_2886_ net2 VGND VGND VPWR VPWR _0167_ sky130_fd_sc_hd__inv_2
XFILLER_57_223 VGND VGND VPWR VPWR sky130_fd_sc_hd__fill_1
X_1699_ my_mul.x2\[3\] acc_reg\[5\] acc_reg\[4\] my_mul.x2\[4\] VGND VGND VPWR VPWR
+ _1243_ sky130_fd_sc_hd__a22oi_1
XFILLER_57_267 VGND VGND VPWR VPWR sky130_fd_sc_hd__decap_3
XFILLER_25_175 VGND VGND VPWR VPWR sky130_fd_sc_hd__decap_3
XFILLER_40_167 VGND VGND VPWR VPWR sky130_fd_sc_hd__decap_3
XFILLER_9_319 VGND VGND VPWR VPWR sky130_fd_sc_hd__decap_3
XFILLER_13_337 VGND VGND VPWR VPWR sky130_fd_sc_hd__fill_1
XFILLER_56_83 VGND VGND VPWR VPWR sky130_fd_sc_hd__fill_1
XFILLER_56_61 VGND VGND VPWR VPWR sky130_fd_sc_hd__decap_3
XFILLER_48_223 VGND VGND VPWR VPWR sky130_fd_sc_hd__decap_3
XFILLER_0_296 VGND VGND VPWR VPWR sky130_fd_sc_hd__decap_3
XFILLER_0_263 VGND VGND VPWR VPWR sky130_fd_sc_hd__decap_3
XTAP_TAPCELL_ROW_46_435 VGND VPWR sky130_fd_sc_hd__tapvpwrvgnd_1
XFILLER_31_101 VGND VGND VPWR VPWR sky130_fd_sc_hd__decap_3
XFILLER_16_197 VGND VGND VPWR VPWR sky130_fd_sc_hd__fill_1
X_1622_ my_mul.x2\[6\] acc_reg\[6\] acc_reg\[5\] _1163_ VGND VGND VPWR VPWR _1166_
+ sky130_fd_sc_hd__a31o_1
X_2740_ net300 _0974_ _1012_ _0972_ VGND VGND VPWR VPWR _1013_ sky130_fd_sc_hd__a22o_1
XFILLER_8_352 VGND VGND VPWR VPWR sky130_fd_sc_hd__fill_2
X_2671_ _0921_ _0928_ _0960_ _0959_ VGND VGND VPWR VPWR _0961_ sky130_fd_sc_hd__or4_4
XFILLER_39_212 VGND VGND VPWR VPWR sky130_fd_sc_hd__decap_3
XFILLER_39_201 VGND VGND VPWR VPWR sky130_fd_sc_hd__decap_3
X_1553_ _1064_ _1066_ _1067_ _1097_ ss_s1 VGND VGND VPWR VPWR _1098_ sky130_fd_sc_hd__a221o_1
XFILLER_54_259 VGND VGND VPWR VPWR sky130_fd_sc_hd__decap_3
X_3085_ clknet_4_6_0_clk _0344_ _0181_ VGND VGND VPWR VPWR acc_reg\[6\] sky130_fd_sc_hd__dfrtp_4
XFILLER_39_256 VGND VGND VPWR VPWR sky130_fd_sc_hd__decap_3
X_2036_ net56 _1099_ _0439_ _0440_ VGND VGND VPWR VPWR _0233_ sky130_fd_sc_hd__o22a_1
X_2105_ net31 shift_in\[15\] _0498_ VGND VGND VPWR VPWR _0222_ sky130_fd_sc_hd__mux2_1
X_3154_ clknet_4_0_0_clk net228 _0065_ VGND VGND VPWR VPWR state\[2\] sky130_fd_sc_hd__dfrtp_1
XFILLER_62_281 VGND VGND VPWR VPWR sky130_fd_sc_hd__decap_3
X_2938_ net2 VGND VGND VPWR VPWR _0034_ sky130_fd_sc_hd__inv_2
XFILLER_10_307 VGND VGND VPWR VPWR sky130_fd_sc_hd__fill_1
XFILLER_10_329 VGND VGND VPWR VPWR sky130_fd_sc_hd__decap_3
X_2869_ net2 VGND VGND VPWR VPWR _0150_ sky130_fd_sc_hd__inv_2
XFILLER_45_248 VGND VGND VPWR VPWR sky130_fd_sc_hd__decap_3
XTAP_TAPCELL_ROW_43_416 VGND VPWR sky130_fd_sc_hd__tapvpwrvgnd_1
XFILLER_42_63 VGND VGND VPWR VPWR sky130_fd_sc_hd__decap_3
Xrebuffer8 net12 VGND VGND VPWR VPWR net13 sky130_fd_sc_hd__buf_1
XFILLER_3_57 VGND VGND VPWR VPWR sky130_fd_sc_hd__decap_3
XFILLER_36_237 VGND VGND VPWR VPWR sky130_fd_sc_hd__fill_2
X_2723_ my_divider.remainder_reg\[7\] net101 VGND VGND VPWR VPWR _0999_ sky130_fd_sc_hd__and2b_1
X_2654_ my_sum_sub.cm_mant\[7\] _0728_ _0741_ _0908_ my_sum_sub.state\[3\] VGND VGND
+ VPWR VPWR _0953_ sky130_fd_sc_hd__o311a_1
X_1605_ _1147_ _1148_ VGND VGND VPWR VPWR _1149_ sky130_fd_sc_hd__xor2_1
X_1536_ net187 bit_count\[0\] _1072_ VGND VGND VPWR VPWR _1083_ sky130_fd_sc_hd__a21o_1
X_2585_ _0864_ _0882_ VGND VGND VPWR VPWR _0884_ sky130_fd_sc_hd__xor2_1
XFILLER_59_329 VGND VGND VPWR VPWR sky130_fd_sc_hd__decap_3
XTAP_TAPCELL_ROW_57_508 VGND VPWR sky130_fd_sc_hd__tapvpwrvgnd_1
X_3137_ clknet_4_7_0_clk net57 _0048_ VGND VGND VPWR VPWR shift_out\[10\] sky130_fd_sc_hd__dfrtp_1
XFILLER_50_251 VGND VGND VPWR VPWR sky130_fd_sc_hd__fill_1
XFILLER_42_218 VGND VGND VPWR VPWR sky130_fd_sc_hd__decap_3
X_3068_ clknet_4_14_0_clk _0327_ _0164_ VGND VGND VPWR VPWR my_sum_sub.cm_mant\[8\]
+ sky130_fd_sc_hd__dfrtp_4
X_2019_ net161 _1091_ _0425_ state\[4\] VGND VGND VPWR VPWR _0426_ sky130_fd_sc_hd__o211a_1
XFILLER_10_104 VGND VGND VPWR VPWR sky130_fd_sc_hd__decap_3
XFILLER_10_148 VGND VGND VPWR VPWR sky130_fd_sc_hd__fill_1
XFILLER_10_159 VGND VGND VPWR VPWR sky130_fd_sc_hd__fill_2
Xhold193 my_sum_sub.cm_mant\[0\] VGND VGND VPWR VPWR net198 sky130_fd_sc_hd__dlygate4sd3_1
Xhold171 my_sum_sub.al_exp\[7\] VGND VGND VPWR VPWR net176 sky130_fd_sc_hd__dlygate4sd3_1
Xhold182 bit_count\[1\] VGND VGND VPWR VPWR net187 sky130_fd_sc_hd__dlygate4sd3_1
Xhold160 div_quotient\[5\] VGND VGND VPWR VPWR net165 sky130_fd_sc_hd__dlygate4sd3_1
XFILLER_58_351 VGND VGND VPWR VPWR sky130_fd_sc_hd__decap_3
XFILLER_37_52 VGND VGND VPWR VPWR sky130_fd_sc_hd__decap_3
XFILLER_37_41 VGND VGND VPWR VPWR sky130_fd_sc_hd__decap_3
XFILLER_33_218 VGND VGND VPWR VPWR sky130_fd_sc_hd__decap_3
XFILLER_53_73 VGND VGND VPWR VPWR sky130_fd_sc_hd__fill_2
XFILLER_53_40 VGND VGND VPWR VPWR sky130_fd_sc_hd__decap_3
XFILLER_45_6 VGND VGND VPWR VPWR sky130_fd_sc_hd__decap_3
XFILLER_5_185 VGND VGND VPWR VPWR sky130_fd_sc_hd__decap_3
X_2370_ _1055_ net257 _0606_ _0630_ _0683_ VGND VGND VPWR VPWR _0306_ sky130_fd_sc_hd__a221o_1
XFILLER_49_340 VGND VGND VPWR VPWR sky130_fd_sc_hd__decap_3
XTAP_TAPCELL_ROW_62_544 VGND VPWR sky130_fd_sc_hd__tapvpwrvgnd_1
XFILLER_24_207 VGND VGND VPWR VPWR sky130_fd_sc_hd__fill_1
XFILLER_17_281 VGND VGND VPWR VPWR sky130_fd_sc_hd__decap_3
XFILLER_32_273 VGND VGND VPWR VPWR sky130_fd_sc_hd__decap_3
X_2706_ _0980_ _0981_ VGND VGND VPWR VPWR _0982_ sky130_fd_sc_hd__nor2_1
XFILLER_59_137 VGND VGND VPWR VPWR sky130_fd_sc_hd__decap_3
XFILLER_59_126 VGND VGND VPWR VPWR sky130_fd_sc_hd__fill_1
XFILLER_58_29 VGND VGND VPWR VPWR sky130_fd_sc_hd__decap_3
XFILLER_58_18 VGND VGND VPWR VPWR sky130_fd_sc_hd__fill_2
X_2499_ _0741_ _0797_ _0742_ my_sum_sub.cm_mant\[4\] VGND VGND VPWR VPWR _0798_ sky130_fd_sc_hd__a2bb2o_1
X_2637_ _0910_ _0919_ _0935_ _0908_ my_sum_sub.cm_exp\[6\] VGND VGND VPWR VPWR _0936_
+ sky130_fd_sc_hd__o32a_1
X_2568_ _0855_ _0861_ _0865_ _0850_ VGND VGND VPWR VPWR _0867_ sky130_fd_sc_hd__nor4b_2
X_1519_ ss_s1 _1063_ _1065_ _1068_ VGND VGND VPWR VPWR _1069_ sky130_fd_sc_hd__o31a_1
XPHY_EDGE_ROW_12_Right_12 VGND VGND VPWR VPWR sky130_fd_sc_hd__decap_3
XPHY_EDGE_ROW_21_Right_21 VGND VGND VPWR VPWR sky130_fd_sc_hd__decap_3
XFILLER_23_251 VGND VGND VPWR VPWR sky130_fd_sc_hd__decap_3
XPHY_EDGE_ROW_30_Right_30 VGND VGND VPWR VPWR sky130_fd_sc_hd__decap_3
XFILLER_2_166 VGND VGND VPWR VPWR sky130_fd_sc_hd__decap_3
XFILLER_61_346 VGND VGND VPWR VPWR sky130_fd_sc_hd__decap_3
XFILLER_61_335 VGND VGND VPWR VPWR sky130_fd_sc_hd__fill_1
XFILLER_61_302 VGND VGND VPWR VPWR sky130_fd_sc_hd__decap_3
XFILLER_58_192 VGND VGND VPWR VPWR sky130_fd_sc_hd__decap_3
XFILLER_46_343 VGND VGND VPWR VPWR sky130_fd_sc_hd__decap_3
XFILLER_46_332 VGND VGND VPWR VPWR sky130_fd_sc_hd__decap_3
X_1870_ _1226_ _1228_ VGND VGND VPWR VPWR _1414_ sky130_fd_sc_hd__and2_1
XTAP_TAPCELL_ROW_24_290 VGND VPWR sky130_fd_sc_hd__tapvpwrvgnd_1
XFILLER_9_23 VGND VGND VPWR VPWR sky130_fd_sc_hd__decap_3
XFILLER_43_3 VGND VGND VPWR VPWR sky130_fd_sc_hd__decap_3
X_2353_ _0660_ _0669_ _1153_ VGND VGND VPWR VPWR _0670_ sky130_fd_sc_hd__mux2_1
X_2422_ my_sum_sub.cm_exp\[6\] _0716_ VGND VGND VPWR VPWR _0721_ sky130_fd_sc_hd__xor2_1
X_2284_ net174 _0608_ net282 VGND VGND VPWR VPWR _0317_ sky130_fd_sc_hd__mux2_1
XFILLER_52_368 VGND VGND VPWR VPWR sky130_fd_sc_hd__fill_2
X_1999_ _1088_ _0407_ VGND VGND VPWR VPWR _0408_ sky130_fd_sc_hd__and2_1
XFILLER_20_287 VGND VGND VPWR VPWR sky130_fd_sc_hd__decap_3
XFILLER_55_184 VGND VGND VPWR VPWR sky130_fd_sc_hd__decap_3
XFILLER_55_151 VGND VGND VPWR VPWR sky130_fd_sc_hd__decap_3
XFILLER_43_346 VGND VGND VPWR VPWR sky130_fd_sc_hd__decap_3
XFILLER_43_324 VGND VGND VPWR VPWR sky130_fd_sc_hd__decap_3
XTAP_TAPCELL_ROW_38_382 VGND VPWR sky130_fd_sc_hd__tapvpwrvgnd_1
XFILLER_28_365 VGND VGND VPWR VPWR sky130_fd_sc_hd__decap_3
XFILLER_28_354 VGND VGND VPWR VPWR sky130_fd_sc_hd__decap_3
XFILLER_28_343 VGND VGND VPWR VPWR sky130_fd_sc_hd__decap_3
XFILLER_18_98 VGND VGND VPWR VPWR sky130_fd_sc_hd__decap_3
XFILLER_50_41 VGND VGND VPWR VPWR sky130_fd_sc_hd__decap_3
XTAP_TAPCELL_ROW_21_271 VGND VPWR sky130_fd_sc_hd__tapvpwrvgnd_1
XFILLER_7_214 VGND VGND VPWR VPWR sky130_fd_sc_hd__fill_1
XFILLER_11_232 VGND VGND VPWR VPWR sky130_fd_sc_hd__decap_3
XFILLER_11_276 VGND VGND VPWR VPWR sky130_fd_sc_hd__decap_3
XFILLER_50_52 VGND VGND VPWR VPWR sky130_fd_sc_hd__fill_2
XFILLER_19_343 VGND VGND VPWR VPWR sky130_fd_sc_hd__fill_1
Xclkbuf_4_11_0_clk clknet_0_clk VGND VGND VPWR VPWR clknet_4_11_0_clk sky130_fd_sc_hd__clkbuf_8
XFILLER_61_198 VGND VGND VPWR VPWR sky130_fd_sc_hd__decap_3
XFILLER_61_187 VGND VGND VPWR VPWR sky130_fd_sc_hd__fill_1
XFILLER_61_143 VGND VGND VPWR VPWR sky130_fd_sc_hd__decap_3
XFILLER_61_110 VGND VGND VPWR VPWR sky130_fd_sc_hd__fill_2
X_1922_ _1465_ VGND VGND VPWR VPWR _1466_ sky130_fd_sc_hd__inv_2
XFILLER_46_184 VGND VGND VPWR VPWR sky130_fd_sc_hd__decap_3
XFILLER_46_162 VGND VGND VPWR VPWR sky130_fd_sc_hd__decap_3
XFILLER_34_368 VGND VGND VPWR VPWR sky130_fd_sc_hd__fill_2
XFILLER_34_335 VGND VGND VPWR VPWR sky130_fd_sc_hd__decap_3
X_2971_ net5 VGND VGND VPWR VPWR _0067_ sky130_fd_sc_hd__inv_2
X_1784_ my_mul.x2\[2\] acc_reg\[3\] _1321_ _1320_ VGND VGND VPWR VPWR _1328_ sky130_fd_sc_hd__a31o_1
X_1853_ _1394_ _1396_ _1393_ VGND VGND VPWR VPWR _1397_ sky130_fd_sc_hd__o21a_1
X_2336_ _0639_ _0654_ _0628_ VGND VGND VPWR VPWR _0655_ sky130_fd_sc_hd__mux2_1
X_2405_ net20 _0702_ _0703_ VGND VGND VPWR VPWR _0704_ sky130_fd_sc_hd__and3_1
X_2198_ _0509_ _0532_ _0510_ VGND VGND VPWR VPWR _0533_ sky130_fd_sc_hd__o21ba_1
XFILLER_37_184 VGND VGND VPWR VPWR sky130_fd_sc_hd__decap_3
XFILLER_37_151 VGND VGND VPWR VPWR sky130_fd_sc_hd__decap_3
X_2267_ my_sum_sub.al_b_larger _0594_ VGND VGND VPWR VPWR _0595_ sky130_fd_sc_hd__nor2_1
XTAP_TAPCELL_ROW_27_308 VGND VPWR sky130_fd_sc_hd__tapvpwrvgnd_1
XFILLER_25_335 VGND VGND VPWR VPWR sky130_fd_sc_hd__fill_1
XTAP_TAPCELL_ROW_35_363 VGND VPWR sky130_fd_sc_hd__tapvpwrvgnd_1
XFILLER_25_368 VGND VGND VPWR VPWR sky130_fd_sc_hd__fill_2
XFILLER_4_217 VGND VGND VPWR VPWR sky130_fd_sc_hd__decap_3
XFILLER_4_228 VGND VGND VPWR VPWR sky130_fd_sc_hd__decap_3
XFILLER_20_22 VGND VGND VPWR VPWR sky130_fd_sc_hd__decap_3
Xhold42 _0225_ VGND VGND VPWR VPWR net47 sky130_fd_sc_hd__dlygate4sd3_1
Xhold64 _0199_ VGND VGND VPWR VPWR net69 sky130_fd_sc_hd__dlygate4sd3_1
Xhold86 shift_in\[11\] VGND VGND VPWR VPWR net91 sky130_fd_sc_hd__dlygate4sd3_1
Xhold53 shift_out\[11\] VGND VGND VPWR VPWR net58 sky130_fd_sc_hd__dlygate4sd3_1
Xhold75 _0249_ VGND VGND VPWR VPWR net80 sky130_fd_sc_hd__dlygate4sd3_1
Xhold97 _0255_ VGND VGND VPWR VPWR net102 sky130_fd_sc_hd__dlygate4sd3_1
Xhold31 _0275_ VGND VGND VPWR VPWR net36 sky130_fd_sc_hd__dlygate4sd3_1
XFILLER_45_63 VGND VGND VPWR VPWR sky130_fd_sc_hd__fill_1
XFILLER_43_176 VGND VGND VPWR VPWR sky130_fd_sc_hd__decap_3
XFILLER_43_154 VGND VGND VPWR VPWR sky130_fd_sc_hd__fill_2
XFILLER_43_110 VGND VGND VPWR VPWR sky130_fd_sc_hd__fill_2
XFILLER_28_195 VGND VGND VPWR VPWR sky130_fd_sc_hd__fill_1
XFILLER_28_162 VGND VGND VPWR VPWR sky130_fd_sc_hd__decap_3
XFILLER_16_324 VGND VGND VPWR VPWR sky130_fd_sc_hd__fill_1
XFILLER_16_346 VGND VGND VPWR VPWR sky130_fd_sc_hd__decap_3
XFILLER_16_357 VGND VGND VPWR VPWR sky130_fd_sc_hd__decap_3
XFILLER_16_368 VGND VGND VPWR VPWR sky130_fd_sc_hd__fill_2
XFILLER_61_51 VGND VGND VPWR VPWR sky130_fd_sc_hd__decap_3
XTAP_TAPCELL_ROW_41_399 VGND VPWR sky130_fd_sc_hd__tapvpwrvgnd_1
XANTENNA_6 acc_reg\[4\] VGND VGND VPWR VPWR sky130_fd_sc_hd__diode_2
XFILLER_6_24 VGND VGND VPWR VPWR sky130_fd_sc_hd__fill_1
X_3170_ clknet_4_1_0_clk net28 _0081_ VGND VGND VPWR VPWR mosi_s1 sky130_fd_sc_hd__dfrtp_1
XFILLER_6_68 VGND VGND VPWR VPWR sky130_fd_sc_hd__decap_3
XTAP_TAPCELL_ROW_49_455 VGND VPWR sky130_fd_sc_hd__tapvpwrvgnd_1
X_2052_ _0390_ _0394_ _0395_ _0398_ VGND VGND VPWR VPWR _0454_ sky130_fd_sc_hd__or4_1
Xrebuffer18 my_sum_sub.cm_exp\[1\] VGND VGND VPWR VPWR net23 sky130_fd_sc_hd__dlygate4sd1_1
X_2121_ _1065_ _1076_ VGND VGND VPWR VPWR _0499_ sky130_fd_sc_hd__nand2_1
X_1905_ _1360_ _1407_ VGND VGND VPWR VPWR _1449_ sky130_fd_sc_hd__xnor2_1
XTAP_TAPCELL_ROW_32_344 VGND VPWR sky130_fd_sc_hd__tapvpwrvgnd_1
X_2885_ net2 VGND VGND VPWR VPWR _0166_ sky130_fd_sc_hd__inv_2
X_2954_ net5 VGND VGND VPWR VPWR _0050_ sky130_fd_sc_hd__inv_2
XFILLER_22_349 VGND VGND VPWR VPWR sky130_fd_sc_hd__fill_2
X_1836_ _1369_ _1370_ VGND VGND VPWR VPWR _1380_ sky130_fd_sc_hd__xnor2_1
X_1698_ _1240_ _1241_ VGND VGND VPWR VPWR _1242_ sky130_fd_sc_hd__or2_1
X_1767_ my_mul.x2\[1\] acc_reg\[6\] _1300_ _1304_ VGND VGND VPWR VPWR _1311_ sky130_fd_sc_hd__a31o_1
XPHY_EDGE_ROW_6_Right_6 VGND VGND VPWR VPWR sky130_fd_sc_hd__decap_3
X_2319_ _0628_ _0639_ VGND VGND VPWR VPWR _0640_ sky130_fd_sc_hd__and2_1
XFILLER_57_279 VGND VGND VPWR VPWR sky130_fd_sc_hd__fill_1
XFILLER_15_22 VGND VGND VPWR VPWR sky130_fd_sc_hd__fill_2
XFILLER_31_98 VGND VGND VPWR VPWR sky130_fd_sc_hd__decap_3
XFILLER_0_253 VGND VGND VPWR VPWR sky130_fd_sc_hd__decap_3
XFILLER_0_231 VGND VGND VPWR VPWR sky130_fd_sc_hd__decap_3
XFILLER_0_220 VGND VGND VPWR VPWR sky130_fd_sc_hd__fill_1
XFILLER_56_40 VGND VGND VPWR VPWR sky130_fd_sc_hd__decap_3
XFILLER_48_235 VGND VGND VPWR VPWR sky130_fd_sc_hd__decap_3
XFILLER_48_202 VGND VGND VPWR VPWR sky130_fd_sc_hd__decap_3
XTAP_TAPCELL_ROW_46_436 VGND VPWR sky130_fd_sc_hd__tapvpwrvgnd_1
XFILLER_0_275 VGND VGND VPWR VPWR sky130_fd_sc_hd__decap_3
XFILLER_16_110 VGND VGND VPWR VPWR sky130_fd_sc_hd__decap_3
XPHY_EDGE_ROW_59_Right_59 VGND VGND VPWR VPWR sky130_fd_sc_hd__decap_3
XFILLER_31_124 VGND VGND VPWR VPWR sky130_fd_sc_hd__decap_3
XFILLER_16_154 VGND VGND VPWR VPWR sky130_fd_sc_hd__fill_1
X_1621_ _1160_ _1163_ _1164_ VGND VGND VPWR VPWR _1165_ sky130_fd_sc_hd__or3_1
X_2670_ _0912_ _0936_ VGND VGND VPWR VPWR _0960_ sky130_fd_sc_hd__nand2_1
X_1552_ state\[4\] _1064_ VGND VGND VPWR VPWR _1097_ sky130_fd_sc_hd__nor2_8
X_2104_ ss_s1 net87 _1063_ sclk_s0 VGND VGND VPWR VPWR _0498_ sky130_fd_sc_hd__or4b_4
X_3153_ clknet_4_0_0_clk _0004_ _0064_ VGND VGND VPWR VPWR state\[1\] sky130_fd_sc_hd__dfrtp_1
XFILLER_62_293 VGND VGND VPWR VPWR sky130_fd_sc_hd__decap_3
XFILLER_62_271 VGND VGND VPWR VPWR sky130_fd_sc_hd__decap_3
XFILLER_47_290 VGND VGND VPWR VPWR sky130_fd_sc_hd__decap_3
X_3084_ clknet_4_7_0_clk _0343_ _0180_ VGND VGND VPWR VPWR acc_reg\[5\] sky130_fd_sc_hd__dfrtp_4
X_2035_ shift_out\[11\] _1064_ _1097_ acc_reg\[10\] _1100_ VGND VGND VPWR VPWR _0440_
+ sky130_fd_sc_hd__a221o_1
X_2868_ net2 VGND VGND VPWR VPWR _0149_ sky130_fd_sc_hd__inv_2
X_2937_ net2 VGND VGND VPWR VPWR _0033_ sky130_fd_sc_hd__inv_2
X_1819_ my_mul.x2\[2\] acc_reg\[0\] VGND VGND VPWR VPWR _1363_ sky130_fd_sc_hd__nand2_1
XFILLER_7_9 VGND VGND VPWR VPWR sky130_fd_sc_hd__fill_1
X_2799_ ss_s1 net185 VGND VGND VPWR VPWR _0008_ sky130_fd_sc_hd__nor2_1
XTAP_TAPCELL_ROW_43_417 VGND VPWR sky130_fd_sc_hd__tapvpwrvgnd_1
XFILLER_42_42 VGND VGND VPWR VPWR sky130_fd_sc_hd__fill_1
Xrebuffer9 my_sum_sub.cm_exp\[2\] VGND VGND VPWR VPWR net14 sky130_fd_sc_hd__dlygate4sd1_1
XFILLER_5_323 VGND VGND VPWR VPWR sky130_fd_sc_hd__decap_3
XFILLER_5_367 VGND VGND VPWR VPWR sky130_fd_sc_hd__decap_3
XFILLER_44_282 VGND VGND VPWR VPWR sky130_fd_sc_hd__decap_3
XFILLER_44_260 VGND VGND VPWR VPWR sky130_fd_sc_hd__decap_3
XFILLER_29_290 VGND VGND VPWR VPWR sky130_fd_sc_hd__decap_3
X_2722_ my_divider.remainder_reg\[6\] _1059_ _0997_ VGND VGND VPWR VPWR _0998_ sky130_fd_sc_hd__a21o_1
XFILLER_12_190 VGND VGND VPWR VPWR sky130_fd_sc_hd__decap_3
XFILLER_59_308 VGND VGND VPWR VPWR sky130_fd_sc_hd__decap_3
X_1604_ my_mul.x2\[13\] acc_reg\[13\] VGND VGND VPWR VPWR _1148_ sky130_fd_sc_hd__nand2_1
X_1535_ bit_count\[0\] _1069_ net187 VGND VGND VPWR VPWR _1082_ sky130_fd_sc_hd__a21oi_1
XFILLER_8_194 VGND VGND VPWR VPWR sky130_fd_sc_hd__fill_2
X_2584_ _0864_ _0882_ VGND VGND VPWR VPWR _0883_ sky130_fd_sc_hd__xnor2_1
X_2653_ _0768_ _0770_ _0776_ _0785_ VGND VGND VPWR VPWR _0952_ sky130_fd_sc_hd__or4_1
X_3067_ clknet_4_15_0_clk _0326_ _0163_ VGND VGND VPWR VPWR my_sum_sub.cm_mant\[7\]
+ sky130_fd_sc_hd__dfrtp_4
X_3136_ clknet_4_5_0_clk net67 _0047_ VGND VGND VPWR VPWR shift_out\[9\] sky130_fd_sc_hd__dfrtp_1
X_2018_ _0421_ _0422_ _0424_ _0408_ _1090_ VGND VGND VPWR VPWR _0425_ sky130_fd_sc_hd__a221o_1
XFILLER_2_304 VGND VGND VPWR VPWR sky130_fd_sc_hd__decap_3
XFILLER_58_330 VGND VGND VPWR VPWR sky130_fd_sc_hd__decap_3
Xhold150 _0311_ VGND VGND VPWR VPWR net155 sky130_fd_sc_hd__dlygate4sd3_1
Xhold194 _0319_ VGND VGND VPWR VPWR net199 sky130_fd_sc_hd__dlygate4sd3_1
Xhold172 _0299_ VGND VGND VPWR VPWR net177 sky130_fd_sc_hd__dlygate4sd3_1
Xhold183 _1082_ VGND VGND VPWR VPWR net188 sky130_fd_sc_hd__dlygate4sd3_1
Xhold161 _0274_ VGND VGND VPWR VPWR net166 sky130_fd_sc_hd__dlygate4sd3_1
XFILLER_58_363 VGND VGND VPWR VPWR sky130_fd_sc_hd__fill_1
XFILLER_41_241 VGND VGND VPWR VPWR sky130_fd_sc_hd__decap_3
XFILLER_5_164 VGND VGND VPWR VPWR sky130_fd_sc_hd__decap_3
XFILLER_5_175 VGND VGND VPWR VPWR sky130_fd_sc_hd__fill_2
XTAP_TAPCELL_ROW_62_545 VGND VPWR sky130_fd_sc_hd__tapvpwrvgnd_1
XFILLER_24_219 VGND VGND VPWR VPWR sky130_fd_sc_hd__decap_3
X_2705_ my_divider.remainder_reg\[4\] my_divider.divisor_reg\[4\] VGND VGND VPWR VPWR
+ _0981_ sky130_fd_sc_hd__and2b_1
X_2636_ _0879_ _0905_ _0876_ VGND VGND VPWR VPWR _0935_ sky130_fd_sc_hd__a21oi_1
X_2498_ my_sum_sub.cm_mant\[7\] _0796_ VGND VGND VPWR VPWR _0797_ sky130_fd_sc_hd__nor2_1
X_2567_ _0855_ _0861_ _0865_ VGND VGND VPWR VPWR _0866_ sky130_fd_sc_hd__or3_1
X_1518_ ss_s1 _1064_ _1067_ VGND VGND VPWR VPWR _1068_ sky130_fd_sc_hd__or3b_1
XFILLER_55_366 VGND VGND VPWR VPWR sky130_fd_sc_hd__decap_3
X_3119_ clknet_4_5_0_clk _0215_ _0030_ VGND VGND VPWR VPWR shift_in\[8\] sky130_fd_sc_hd__dfrtp_1
XTAP_TAPCELL_ROW_2_145 VGND VPWR sky130_fd_sc_hd__tapvpwrvgnd_1
XFILLER_58_171 VGND VGND VPWR VPWR sky130_fd_sc_hd__decap_3
XFILLER_48_85 VGND VGND VPWR VPWR sky130_fd_sc_hd__fill_2
XFILLER_48_41 VGND VGND VPWR VPWR sky130_fd_sc_hd__fill_1
XFILLER_0_15 VGND VGND VPWR VPWR sky130_fd_sc_hd__fill_1
XFILLER_61_358 VGND VGND VPWR VPWR sky130_fd_sc_hd__decap_3
XFILLER_61_314 VGND VGND VPWR VPWR sky130_fd_sc_hd__decap_3
XTAP_TAPCELL_ROW_16_236 VGND VPWR sky130_fd_sc_hd__tapvpwrvgnd_1
XTAP_TAPCELL_ROW_24_291 VGND VPWR sky130_fd_sc_hd__tapvpwrvgnd_1
X_2352_ _0668_ _0667_ _0604_ VGND VGND VPWR VPWR _0669_ sky130_fd_sc_hd__mux2_1
XFILLER_36_3 VGND VGND VPWR VPWR sky130_fd_sc_hd__decap_3
X_2283_ net279 net156 VGND VGND VPWR VPWR _0608_ sky130_fd_sc_hd__xor2_1
X_2421_ _0713_ _0714_ _0716_ _0717_ _0705_ VGND VGND VPWR VPWR _0720_ sky130_fd_sc_hd__o221a_4
XFILLER_56_108 VGND VGND VPWR VPWR sky130_fd_sc_hd__decap_3
X_1998_ _0383_ _0406_ VGND VGND VPWR VPWR _0407_ sky130_fd_sc_hd__xnor2_4
X_2619_ _0917_ VGND VGND VPWR VPWR _0918_ sky130_fd_sc_hd__inv_2
XFILLER_55_163 VGND VGND VPWR VPWR sky130_fd_sc_hd__decap_3
XTAP_TAPCELL_ROW_38_383 VGND VPWR sky130_fd_sc_hd__tapvpwrvgnd_1
XFILLER_34_32 VGND VGND VPWR VPWR sky130_fd_sc_hd__fill_2
XFILLER_34_65 VGND VGND VPWR VPWR sky130_fd_sc_hd__fill_2
XTAP_TAPCELL_ROW_21_272 VGND VPWR sky130_fd_sc_hd__tapvpwrvgnd_1
XFILLER_11_211 VGND VGND VPWR VPWR sky130_fd_sc_hd__decap_3
XFILLER_11_244 VGND VGND VPWR VPWR sky130_fd_sc_hd__decap_3
XFILLER_11_299 VGND VGND VPWR VPWR sky130_fd_sc_hd__decap_3
XTAP_TAPCELL_ROW_13_217 VGND VPWR sky130_fd_sc_hd__tapvpwrvgnd_1
XFILLER_59_84 VGND VGND VPWR VPWR sky130_fd_sc_hd__decap_3
XFILLER_50_97 VGND VGND VPWR VPWR sky130_fd_sc_hd__decap_3
XFILLER_19_322 VGND VGND VPWR VPWR sky130_fd_sc_hd__decap_3
XFILLER_61_166 VGND VGND VPWR VPWR sky130_fd_sc_hd__fill_2
X_1921_ _1286_ _1411_ VGND VGND VPWR VPWR _1465_ sky130_fd_sc_hd__xor2_1
X_1852_ _1394_ _1395_ my_mul.x2\[2\] acc_reg\[0\] VGND VGND VPWR VPWR _1396_ sky130_fd_sc_hd__and4b_1
X_2970_ net2 VGND VGND VPWR VPWR _0066_ sky130_fd_sc_hd__inv_2
X_1783_ my_mul.x2\[0\] acc_reg\[6\] VGND VGND VPWR VPWR _1327_ sky130_fd_sc_hd__nand2_1
X_2335_ _1153_ _0622_ _0652_ _0653_ VGND VGND VPWR VPWR _0654_ sky130_fd_sc_hd__a31o_1
X_2266_ my_sum_sub.al_mb\[0\] my_sum_sub.al_ma\[0\] VGND VGND VPWR VPWR _0594_ sky130_fd_sc_hd__xnor2_1
X_2404_ my_sum_sub.cm_exp\[7\] my_sum_sub.cm_exp\[6\] my_sum_sub.cm_exp\[1\] VGND
+ VGND VPWR VPWR _0703_ sky130_fd_sc_hd__and3_1
X_2197_ _0511_ _0531_ _0512_ VGND VGND VPWR VPWR _0532_ sky130_fd_sc_hd__o21ba_1
XFILLER_52_144 VGND VGND VPWR VPWR sky130_fd_sc_hd__fill_2
XFILLER_37_130 VGND VGND VPWR VPWR sky130_fd_sc_hd__decap_3
XTAP_TAPCELL_ROW_35_364 VGND VPWR sky130_fd_sc_hd__tapvpwrvgnd_1
XTAP_TAPCELL_ROW_27_309 VGND VPWR sky130_fd_sc_hd__tapvpwrvgnd_1
XFILLER_45_20 VGND VGND VPWR VPWR sky130_fd_sc_hd__fill_1
Xhold76 shift_in\[9\] VGND VGND VPWR VPWR net81 sky130_fd_sc_hd__dlygate4sd3_1
Xhold87 shift_in\[7\] VGND VGND VPWR VPWR net92 sky130_fd_sc_hd__dlygate4sd3_1
Xhold98 my_sum_sub.al_exp\[2\] VGND VGND VPWR VPWR net103 sky130_fd_sc_hd__dlygate4sd3_1
XFILLER_28_174 VGND VGND VPWR VPWR sky130_fd_sc_hd__fill_2
Xhold54 _0234_ VGND VGND VPWR VPWR net59 sky130_fd_sc_hd__dlygate4sd3_1
Xhold65 my_divider.divisor_reg\[2\] VGND VGND VPWR VPWR net70 sky130_fd_sc_hd__dlygate4sd3_1
Xhold32 my_sum_sub.result\[3\] VGND VGND VPWR VPWR net37 sky130_fd_sc_hd__dlygate4sd3_1
Xhold43 my_sum_sub.result\[1\] VGND VGND VPWR VPWR net48 sky130_fd_sc_hd__dlygate4sd3_1
XFILLER_61_30 VGND VGND VPWR VPWR sky130_fd_sc_hd__decap_3
XFILLER_45_75 VGND VGND VPWR VPWR sky130_fd_sc_hd__fill_2
XFILLER_45_53 VGND VGND VPWR VPWR sky130_fd_sc_hd__decap_3
XFILLER_43_166 VGND VGND VPWR VPWR sky130_fd_sc_hd__fill_2
XFILLER_43_122 VGND VGND VPWR VPWR sky130_fd_sc_hd__fill_1
X_2120_ shift_in\[1\] net121 net88 VGND VGND VPWR VPWR _0207_ sky130_fd_sc_hd__mux2_1
XFILLER_3_284 VGND VGND VPWR VPWR sky130_fd_sc_hd__decap_3
XTAP_TAPCELL_ROW_49_456 VGND VPWR sky130_fd_sc_hd__tapvpwrvgnd_1
X_2051_ _1447_ _0379_ _0372_ _0369_ VGND VGND VPWR VPWR _0453_ sky130_fd_sc_hd__a211oi_1
XFILLER_34_144 VGND VGND VPWR VPWR sky130_fd_sc_hd__decap_3
XFILLER_22_306 VGND VGND VPWR VPWR sky130_fd_sc_hd__fill_2
Xrebuffer19 my_sum_sub.cm_exp\[0\] VGND VGND VPWR VPWR net24 sky130_fd_sc_hd__dlygate4sd1_1
X_1835_ _1373_ _1374_ VGND VGND VPWR VPWR _1379_ sky130_fd_sc_hd__xnor2_1
X_1904_ _1378_ _1406_ VGND VGND VPWR VPWR _1448_ sky130_fd_sc_hd__xnor2_1
XTAP_TAPCELL_ROW_32_345 VGND VPWR sky130_fd_sc_hd__tapvpwrvgnd_1
X_2884_ net2 VGND VGND VPWR VPWR _0165_ sky130_fd_sc_hd__inv_2
X_2953_ net5 VGND VGND VPWR VPWR _0049_ sky130_fd_sc_hd__inv_2
XFILLER_22_339 VGND VGND VPWR VPWR sky130_fd_sc_hd__decap_3
X_1697_ _1213_ _1234_ _1239_ VGND VGND VPWR VPWR _1241_ sky130_fd_sc_hd__o21ba_1
X_1766_ _1307_ _1308_ VGND VGND VPWR VPWR _1310_ sky130_fd_sc_hd__or2_1
XFILLER_57_225 VGND VGND VPWR VPWR sky130_fd_sc_hd__decap_3
X_2249_ net274 _0580_ net127 VGND VGND VPWR VPWR _0324_ sky130_fd_sc_hd__mux2_1
X_2318_ _0632_ _0638_ _1153_ VGND VGND VPWR VPWR _0639_ sky130_fd_sc_hd__mux2_1
XFILLER_25_199 VGND VGND VPWR VPWR sky130_fd_sc_hd__decap_3
XFILLER_25_166 VGND VGND VPWR VPWR sky130_fd_sc_hd__fill_2
Xclkbuf_4_10_0_clk clknet_0_clk VGND VGND VPWR VPWR clknet_4_10_0_clk sky130_fd_sc_hd__clkbuf_8
XFILLER_0_287 VGND VGND VPWR VPWR sky130_fd_sc_hd__decap_3
XFILLER_0_243 VGND VGND VPWR VPWR sky130_fd_sc_hd__decap_3
XFILLER_56_85 VGND VGND VPWR VPWR sky130_fd_sc_hd__decap_3
XFILLER_56_52 VGND VGND VPWR VPWR sky130_fd_sc_hd__decap_3
XFILLER_48_258 VGND VGND VPWR VPWR sky130_fd_sc_hd__decap_3
XTAP_TAPCELL_ROW_46_437 VGND VPWR sky130_fd_sc_hd__tapvpwrvgnd_1
XFILLER_12_361 VGND VGND VPWR VPWR sky130_fd_sc_hd__decap_3
X_1620_ _1161_ _1162_ my_mul.x2\[5\] VGND VGND VPWR VPWR _1164_ sky130_fd_sc_hd__a21oi_1
X_1551_ net202 _1066_ VGND VGND VPWR VPWR _1096_ sky130_fd_sc_hd__nor2_1
XFILLER_8_365 VGND VGND VPWR VPWR sky130_fd_sc_hd__decap_3
XFILLER_54_217 VGND VGND VPWR VPWR sky130_fd_sc_hd__decap_3
X_3083_ clknet_4_5_0_clk net313 _0179_ VGND VGND VPWR VPWR acc_reg\[4\] sky130_fd_sc_hd__dfrtp_4
X_2103_ net221 _1099_ _0496_ _0497_ VGND VGND VPWR VPWR _0223_ sky130_fd_sc_hd__o22a_1
X_3152_ clknet_4_0_0_clk _0007_ _0063_ VGND VGND VPWR VPWR state\[0\] sky130_fd_sc_hd__dfstp_1
X_2034_ net179 _1091_ _0438_ state\[4\] VGND VGND VPWR VPWR _0439_ sky130_fd_sc_hd__o211a_1
X_1818_ _1351_ _1352_ VGND VGND VPWR VPWR _1362_ sky130_fd_sc_hd__xnor2_1
X_2867_ net2 VGND VGND VPWR VPWR _0148_ sky130_fd_sc_hd__inv_2
X_2936_ net2 VGND VGND VPWR VPWR _0032_ sky130_fd_sc_hd__inv_2
Xhold310 ss_s0 VGND VGND VPWR VPWR net315 sky130_fd_sc_hd__dlygate4sd3_1
X_2798_ state\[3\] _0499_ net184 VGND VGND VPWR VPWR _1048_ sky130_fd_sc_hd__a21oi_1
XFILLER_10_309 VGND VGND VPWR VPWR sky130_fd_sc_hd__fill_2
X_1749_ my_mul.x2\[2\] acc_reg\[4\] VGND VGND VPWR VPWR _1293_ sky130_fd_sc_hd__nand2_1
XFILLER_53_250 VGND VGND VPWR VPWR sky130_fd_sc_hd__fill_2
XFILLER_42_32 VGND VGND VPWR VPWR sky130_fd_sc_hd__fill_1
XFILLER_13_158 VGND VGND VPWR VPWR sky130_fd_sc_hd__fill_1
XFILLER_13_169 VGND VGND VPWR VPWR sky130_fd_sc_hd__fill_2
XPHY_EDGE_ROW_39_Left_102 VGND VGND VPWR VPWR sky130_fd_sc_hd__decap_3
XFILLER_5_313 VGND VGND VPWR VPWR sky130_fd_sc_hd__fill_1
XFILLER_5_335 VGND VGND VPWR VPWR sky130_fd_sc_hd__fill_1
XPHY_EDGE_ROW_48_Left_111 VGND VGND VPWR VPWR sky130_fd_sc_hd__decap_3
XFILLER_3_48 VGND VGND VPWR VPWR sky130_fd_sc_hd__decap_3
XTAP_TAPCELL_ROW_8_184 VGND VPWR sky130_fd_sc_hd__tapvpwrvgnd_1
XFILLER_36_228 VGND VGND VPWR VPWR sky130_fd_sc_hd__decap_3
XPHY_EDGE_ROW_57_Left_120 VGND VGND VPWR VPWR sky130_fd_sc_hd__decap_3
X_2721_ _0977_ _0996_ _0976_ VGND VGND VPWR VPWR _0997_ sky130_fd_sc_hd__o21a_1
X_2652_ _0836_ _0837_ _0847_ VGND VGND VPWR VPWR _0951_ sky130_fd_sc_hd__or3_1
X_1603_ _1145_ _1146_ VGND VGND VPWR VPWR _1147_ sky130_fd_sc_hd__nand2_2
X_1534_ _1079_ net234 VGND VGND VPWR VPWR _0241_ sky130_fd_sc_hd__and2b_1
X_2583_ _0820_ _0850_ _0861_ _0863_ _0854_ VGND VGND VPWR VPWR _0882_ sky130_fd_sc_hd__o311a_4
X_3066_ clknet_4_15_0_clk net244 _0162_ VGND VGND VPWR VPWR my_sum_sub.cm_mant\[6\]
+ sky130_fd_sc_hd__dfrtp_2
X_3135_ clknet_4_6_0_clk net43 _0046_ VGND VGND VPWR VPWR shift_out\[8\] sky130_fd_sc_hd__dfrtp_1
X_2017_ _0423_ VGND VGND VPWR VPWR _0424_ sky130_fd_sc_hd__inv_2
XFILLER_50_253 VGND VGND VPWR VPWR sky130_fd_sc_hd__fill_2
XFILLER_50_242 VGND VGND VPWR VPWR sky130_fd_sc_hd__fill_1
X_2919_ net5 VGND VGND VPWR VPWR _0015_ sky130_fd_sc_hd__inv_2
Xhold162 shift_in\[2\] VGND VGND VPWR VPWR net167 sky130_fd_sc_hd__dlygate4sd3_1
Xhold151 my_mul.x2\[15\] VGND VGND VPWR VPWR net156 sky130_fd_sc_hd__dlygate4sd3_1
Xhold140 _0259_ VGND VGND VPWR VPWR net145 sky130_fd_sc_hd__dlygate4sd3_1
XFILLER_58_342 VGND VGND VPWR VPWR sky130_fd_sc_hd__decap_3
XFILLER_37_32 VGND VGND VPWR VPWR sky130_fd_sc_hd__decap_3
Xhold184 _0240_ VGND VGND VPWR VPWR net189 sky130_fd_sc_hd__dlygate4sd3_1
Xhold195 my_divider.remainder_reg\[5\] VGND VGND VPWR VPWR net200 sky130_fd_sc_hd__dlygate4sd3_1
XTAP_TAPCELL_ROW_5_165 VGND VPWR sky130_fd_sc_hd__tapvpwrvgnd_1
Xhold173 my_sum_sub.start VGND VGND VPWR VPWR net178 sky130_fd_sc_hd__dlygate4sd3_1
XFILLER_33_209 VGND VGND VPWR VPWR sky130_fd_sc_hd__decap_3
XFILLER_26_250 VGND VGND VPWR VPWR sky130_fd_sc_hd__fill_2
XFILLER_53_64 VGND VGND VPWR VPWR sky130_fd_sc_hd__decap_3
XFILLER_41_275 VGND VGND VPWR VPWR sky130_fd_sc_hd__decap_3
XFILLER_5_143 VGND VGND VPWR VPWR sky130_fd_sc_hd__fill_2
XTAP_TAPCELL_ROW_19_256 VGND VPWR sky130_fd_sc_hd__tapvpwrvgnd_1
XTAP_TAPCELL_ROW_62_546 VGND VPWR sky130_fd_sc_hd__tapvpwrvgnd_1
XTAP_TAPCELL_ROW_62_535 VGND VPWR sky130_fd_sc_hd__tapvpwrvgnd_1
XFILLER_17_272 VGND VGND VPWR VPWR sky130_fd_sc_hd__decap_3
X_2704_ my_divider.divisor_reg\[4\] my_divider.remainder_reg\[4\] VGND VGND VPWR VPWR
+ _0980_ sky130_fd_sc_hd__and2b_1
X_2635_ _0933_ VGND VGND VPWR VPWR _0934_ sky130_fd_sc_hd__inv_2
X_2497_ net8 my_sum_sub.cm_mant\[5\] VGND VGND VPWR VPWR _0796_ sky130_fd_sc_hd__and2b_1
X_2566_ _0820_ _0857_ _0862_ VGND VGND VPWR VPWR _0865_ sky130_fd_sc_hd__or3_2
X_1517_ state\[2\] state\[0\] VGND VGND VPWR VPWR _1067_ sky130_fd_sc_hd__nor2_1
XFILLER_55_356 VGND VGND VPWR VPWR sky130_fd_sc_hd__fill_2
X_3049_ clknet_4_15_0_clk net218 _0145_ VGND VGND VPWR VPWR my_sum_sub.al_mb\[0\]
+ sky130_fd_sc_hd__dfrtp_2
X_3118_ clknet_4_5_0_clk _0214_ _0029_ VGND VGND VPWR VPWR shift_in\[7\] sky130_fd_sc_hd__dfrtp_1
XFILLER_23_220 VGND VGND VPWR VPWR sky130_fd_sc_hd__decap_3
XTAP_TAPCELL_ROW_2_146 VGND VPWR sky130_fd_sc_hd__tapvpwrvgnd_1
XFILLER_15_209 VGND VGND VPWR VPWR sky130_fd_sc_hd__decap_3
XFILLER_58_183 VGND VGND VPWR VPWR sky130_fd_sc_hd__decap_3
XFILLER_46_323 VGND VGND VPWR VPWR sky130_fd_sc_hd__decap_3
XFILLER_61_337 VGND VGND VPWR VPWR sky130_fd_sc_hd__decap_3
XFILLER_61_326 VGND VGND VPWR VPWR sky130_fd_sc_hd__decap_3
XFILLER_14_297 VGND VGND VPWR VPWR sky130_fd_sc_hd__decap_3
XTAP_TAPCELL_ROW_16_237 VGND VPWR sky130_fd_sc_hd__tapvpwrvgnd_1
XFILLER_50_6 VGND VGND VPWR VPWR sky130_fd_sc_hd__decap_3
XTAP_TAPCELL_ROW_24_292 VGND VPWR sky130_fd_sc_hd__tapvpwrvgnd_1
XPHY_EDGE_ROW_24_Left_87 VGND VGND VPWR VPWR sky130_fd_sc_hd__decap_3
X_2420_ _0704_ _0715_ VGND VGND VPWR VPWR _0719_ sky130_fd_sc_hd__nor2_1
X_2351_ my_mul.x2\[1\] _0623_ VGND VGND VPWR VPWR _0668_ sky130_fd_sc_hd__and2_1
X_2282_ net305 _1055_ _0607_ VGND VGND VPWR VPWR _0318_ sky130_fd_sc_hd__a21o_1
XFILLER_29_3 VGND VGND VPWR VPWR sky130_fd_sc_hd__decap_3
X_1997_ _1147_ _0404_ VGND VGND VPWR VPWR _0406_ sky130_fd_sc_hd__nand2b_2
X_2549_ _0837_ _0847_ VGND VGND VPWR VPWR _0848_ sky130_fd_sc_hd__and2_1
XFILLER_9_290 VGND VGND VPWR VPWR sky130_fd_sc_hd__fill_2
X_2618_ net14 _0908_ _0915_ _0916_ VGND VGND VPWR VPWR _0917_ sky130_fd_sc_hd__a2bb2o_1
XFILLER_55_142 VGND VGND VPWR VPWR sky130_fd_sc_hd__decap_3
XFILLER_55_131 VGND VGND VPWR VPWR sky130_fd_sc_hd__decap_3
XFILLER_47_109 VGND VGND VPWR VPWR sky130_fd_sc_hd__decap_3
XFILLER_55_175 VGND VGND VPWR VPWR sky130_fd_sc_hd__decap_3
XTAP_TAPCELL_ROW_38_384 VGND VPWR sky130_fd_sc_hd__tapvpwrvgnd_1
XTAP_TAPCELL_ROW_13_218 VGND VPWR sky130_fd_sc_hd__tapvpwrvgnd_1
XFILLER_50_76 VGND VGND VPWR VPWR sky130_fd_sc_hd__decap_3
XFILLER_50_32 VGND VGND VPWR VPWR sky130_fd_sc_hd__decap_3
XTAP_TAPCELL_ROW_21_273 VGND VPWR sky130_fd_sc_hd__tapvpwrvgnd_1
XFILLER_11_256 VGND VGND VPWR VPWR sky130_fd_sc_hd__decap_3
XFILLER_59_63 VGND VGND VPWR VPWR sky130_fd_sc_hd__decap_3
XFILLER_59_41 VGND VGND VPWR VPWR sky130_fd_sc_hd__decap_3
XFILLER_59_30 VGND VGND VPWR VPWR sky130_fd_sc_hd__fill_2
XFILLER_38_109 VGND VGND VPWR VPWR sky130_fd_sc_hd__decap_3
XFILLER_46_197 VGND VGND VPWR VPWR sky130_fd_sc_hd__decap_3
XFILLER_19_334 VGND VGND VPWR VPWR sky130_fd_sc_hd__fill_2
XFILLER_19_312 VGND VGND VPWR VPWR sky130_fd_sc_hd__fill_2
XFILLER_15_9 VGND VGND VPWR VPWR sky130_fd_sc_hd__fill_1
X_1920_ _1257_ _1412_ VGND VGND VPWR VPWR _1464_ sky130_fd_sc_hd__xnor2_1
X_1851_ my_mul.x2\[0\] acc_reg\[2\] acc_reg\[1\] my_mul.x2\[1\] VGND VGND VPWR VPWR
+ _1395_ sky130_fd_sc_hd__a22o_1
X_1782_ _1318_ _1324_ VGND VGND VPWR VPWR _1326_ sky130_fd_sc_hd__xor2_1
X_2403_ my_sum_sub.cm_exp\[5\] my_sum_sub.cm_exp\[4\] my_sum_sub.cm_exp\[3\] my_sum_sub.cm_exp\[2\]
+ VGND VGND VPWR VPWR _0702_ sky130_fd_sc_hd__and4_2
X_2196_ _0513_ _0530_ VGND VGND VPWR VPWR _0531_ sky130_fd_sc_hd__or2_1
X_2334_ _1153_ _0645_ VGND VGND VPWR VPWR _0653_ sky130_fd_sc_hd__and2b_1
X_2265_ net217 _0553_ _0525_ VGND VGND VPWR VPWR _0593_ sky130_fd_sc_hd__o21a_1
XFILLER_37_142 VGND VGND VPWR VPWR sky130_fd_sc_hd__decap_3
XFILLER_52_167 VGND VGND VPWR VPWR sky130_fd_sc_hd__decap_3
XFILLER_52_134 VGND VGND VPWR VPWR sky130_fd_sc_hd__decap_3
XFILLER_40_318 VGND VGND VPWR VPWR sky130_fd_sc_hd__decap_3
XFILLER_40_307 VGND VGND VPWR VPWR sky130_fd_sc_hd__fill_1
XFILLER_37_164 VGND VGND VPWR VPWR sky130_fd_sc_hd__decap_3
XTAP_TAPCELL_ROW_35_365 VGND VPWR sky130_fd_sc_hd__tapvpwrvgnd_1
XFILLER_25_337 VGND VGND VPWR VPWR sky130_fd_sc_hd__decap_3
XFILLER_20_13 VGND VGND VPWR VPWR sky130_fd_sc_hd__decap_3
XFILLER_4_208 VGND VGND VPWR VPWR sky130_fd_sc_hd__decap_3
XFILLER_29_44 VGND VGND VPWR VPWR sky130_fd_sc_hd__decap_3
XFILLER_20_35 VGND VGND VPWR VPWR sky130_fd_sc_hd__fill_2
Xhold22 net316 VGND VGND VPWR VPWR net27 sky130_fd_sc_hd__dlygate4sd3_1
XFILLER_45_32 VGND VGND VPWR VPWR sky130_fd_sc_hd__decap_3
Xhold44 shift_out\[1\] VGND VGND VPWR VPWR net49 sky130_fd_sc_hd__dlygate4sd3_1
Xhold55 shift_out\[5\] VGND VGND VPWR VPWR net60 sky130_fd_sc_hd__dlygate4sd3_1
Xhold77 _0200_ VGND VGND VPWR VPWR net82 sky130_fd_sc_hd__dlygate4sd3_1
XFILLER_28_197 VGND VGND VPWR VPWR sky130_fd_sc_hd__decap_3
Xhold99 _0331_ VGND VGND VPWR VPWR net104 sky130_fd_sc_hd__dlygate4sd3_1
Xhold33 shift_out\[14\] VGND VGND VPWR VPWR net38 sky130_fd_sc_hd__dlygate4sd3_1
Xhold66 _0250_ VGND VGND VPWR VPWR net71 sky130_fd_sc_hd__dlygate4sd3_1
Xhold88 my_divider.divisor_reg\[4\] VGND VGND VPWR VPWR net93 sky130_fd_sc_hd__dlygate4sd3_1
XFILLER_16_304 VGND VGND VPWR VPWR sky130_fd_sc_hd__decap_3
XFILLER_16_315 VGND VGND VPWR VPWR sky130_fd_sc_hd__decap_3
XFILLER_61_42 VGND VGND VPWR VPWR sky130_fd_sc_hd__fill_2
XFILLER_43_189 VGND VGND VPWR VPWR sky130_fd_sc_hd__decap_3
XFILLER_3_252 VGND VGND VPWR VPWR sky130_fd_sc_hd__fill_1
X_2050_ net42 _1099_ _0451_ _0452_ VGND VGND VPWR VPWR _0231_ sky130_fd_sc_hd__o22a_1
XFILLER_34_167 VGND VGND VPWR VPWR sky130_fd_sc_hd__decap_3
XFILLER_34_156 VGND VGND VPWR VPWR sky130_fd_sc_hd__fill_2
X_2952_ net5 VGND VGND VPWR VPWR _0048_ sky130_fd_sc_hd__inv_2
XFILLER_19_175 VGND VGND VPWR VPWR sky130_fd_sc_hd__decap_3
XFILLER_19_164 VGND VGND VPWR VPWR sky130_fd_sc_hd__decap_3
XFILLER_19_153 VGND VGND VPWR VPWR sky130_fd_sc_hd__decap_3
X_1834_ _1376_ _1377_ VGND VGND VPWR VPWR _1378_ sky130_fd_sc_hd__nand2_1
X_1765_ _1307_ _1308_ VGND VGND VPWR VPWR _1309_ sky130_fd_sc_hd__nor2_1
X_1903_ _1153_ _1423_ VGND VGND VPWR VPWR _1447_ sky130_fd_sc_hd__xnor2_1
X_2883_ net2 VGND VGND VPWR VPWR _0164_ sky130_fd_sc_hd__inv_2
XTAP_TAPCELL_ROW_32_346 VGND VPWR sky130_fd_sc_hd__tapvpwrvgnd_1
X_1696_ _1213_ _1234_ _1239_ VGND VGND VPWR VPWR _1240_ sky130_fd_sc_hd__nor3b_1
XPHY_EDGE_ROW_27_Left_90 VGND VGND VPWR VPWR sky130_fd_sc_hd__decap_3
X_2179_ my_sum_sub.al_mb\[5\] net211 VGND VGND VPWR VPWR _0514_ sky130_fd_sc_hd__and2b_1
X_2248_ _0543_ _0579_ VGND VGND VPWR VPWR _0580_ sky130_fd_sc_hd__xnor2_1
X_2317_ _0604_ _0637_ _0636_ _0622_ VGND VGND VPWR VPWR _0638_ sky130_fd_sc_hd__o211a_1
XFILLER_25_101 VGND VGND VPWR VPWR sky130_fd_sc_hd__decap_3
XPHY_EDGE_ROW_11_Left_74 VGND VGND VPWR VPWR sky130_fd_sc_hd__decap_3
XFILLER_25_178 VGND VGND VPWR VPWR sky130_fd_sc_hd__fill_2
XFILLER_15_57 VGND VGND VPWR VPWR sky130_fd_sc_hd__fill_1
XFILLER_48_226 VGND VGND VPWR VPWR sky130_fd_sc_hd__decap_3
XFILLER_0_299 VGND VGND VPWR VPWR sky130_fd_sc_hd__decap_3
XFILLER_0_266 VGND VGND VPWR VPWR sky130_fd_sc_hd__decap_3
XFILLER_0_200 VGND VGND VPWR VPWR sky130_fd_sc_hd__fill_2
XFILLER_0_211 VGND VGND VPWR VPWR sky130_fd_sc_hd__fill_1
XFILLER_56_64 VGND VGND VPWR VPWR sky130_fd_sc_hd__decap_3
XFILLER_8_322 VGND VGND VPWR VPWR sky130_fd_sc_hd__fill_1
X_1550_ _1092_ _1094_ VGND VGND VPWR VPWR _1095_ sky130_fd_sc_hd__or2_4
XFILLER_54_229 VGND VGND VPWR VPWR sky130_fd_sc_hd__fill_1
XFILLER_47_281 VGND VGND VPWR VPWR sky130_fd_sc_hd__decap_3
X_3082_ clknet_4_7_0_clk _0341_ _0178_ VGND VGND VPWR VPWR acc_reg\[3\] sky130_fd_sc_hd__dfrtp_4
XFILLER_39_215 VGND VGND VPWR VPWR sky130_fd_sc_hd__fill_1
XFILLER_39_204 VGND VGND VPWR VPWR sky130_fd_sc_hd__decap_3
X_2102_ net49 _1064_ _1097_ acc_reg\[0\] _1100_ VGND VGND VPWR VPWR _0497_ sky130_fd_sc_hd__a221o_1
X_2033_ _0369_ _0373_ _0435_ _0437_ VGND VGND VPWR VPWR _0438_ sky130_fd_sc_hd__o31ai_1
XFILLER_11_3 VGND VGND VPWR VPWR sky130_fd_sc_hd__decap_3
X_3151_ clknet_4_1_0_clk _0247_ _0062_ VGND VGND VPWR VPWR my_sum_sub.operation sky130_fd_sc_hd__dfrtp_2
XFILLER_62_284 VGND VGND VPWR VPWR sky130_fd_sc_hd__decap_3
XFILLER_62_262 VGND VGND VPWR VPWR sky130_fd_sc_hd__decap_3
XFILLER_62_240 VGND VGND VPWR VPWR sky130_fd_sc_hd__decap_3
X_2935_ net5 VGND VGND VPWR VPWR _0031_ sky130_fd_sc_hd__inv_2
X_1748_ _1290_ _1291_ VGND VGND VPWR VPWR _1292_ sky130_fd_sc_hd__nor2_1
X_1817_ _1355_ _1356_ VGND VGND VPWR VPWR _1361_ sky130_fd_sc_hd__xor2_1
X_2866_ net2 VGND VGND VPWR VPWR _0147_ sky130_fd_sc_hd__inv_2
Xhold300 my_sum_sub.al_b_larger VGND VGND VPWR VPWR net305 sky130_fd_sc_hd__dlygate4sd3_1
XFILLER_30_181 VGND VGND VPWR VPWR sky130_fd_sc_hd__decap_3
Xhold311 my_mul.reg1en.d\[0\] VGND VGND VPWR VPWR net316 sky130_fd_sc_hd__dlygate4sd3_1
X_2797_ net182 _1087_ _1094_ _1060_ VGND VGND VPWR VPWR _0009_ sky130_fd_sc_hd__o31a_1
X_1679_ my_mul.x2\[2\] _1218_ _1217_ VGND VGND VPWR VPWR _1223_ sky130_fd_sc_hd__a21oi_1
XFILLER_26_23 VGND VGND VPWR VPWR sky130_fd_sc_hd__decap_3
XTAP_TAPCELL_ROW_8_185 VGND VPWR sky130_fd_sc_hd__tapvpwrvgnd_1
XFILLER_44_251 VGND VGND VPWR VPWR sky130_fd_sc_hd__fill_1
XFILLER_59_3 VGND VGND VPWR VPWR sky130_fd_sc_hd__decap_3
X_1602_ my_mul.x2\[14\] acc_reg\[14\] VGND VGND VPWR VPWR _1146_ sky130_fd_sc_hd__nand2_1
X_2720_ _0980_ _0995_ _0979_ VGND VGND VPWR VPWR _0996_ sky130_fd_sc_hd__o21a_1
X_2582_ _0850_ _0861_ _0865_ _0854_ VGND VGND VPWR VPWR _0881_ sky130_fd_sc_hd__o31ai_4
X_2651_ _0880_ _0890_ _0948_ VGND VGND VPWR VPWR _0950_ sky130_fd_sc_hd__o21ai_1
X_1533_ net187 bit_count\[0\] _1069_ net233 VGND VGND VPWR VPWR _1081_ sky130_fd_sc_hd__a31o_1
X_3065_ clknet_4_15_0_clk net275 _0161_ VGND VGND VPWR VPWR my_sum_sub.cm_mant\[5\]
+ sky130_fd_sc_hd__dfrtp_2
X_3134_ clknet_4_6_0_clk net52 _0045_ VGND VGND VPWR VPWR shift_out\[7\] sky130_fd_sc_hd__dfrtp_1
X_2016_ _1112_ _0405_ VGND VGND VPWR VPWR _0423_ sky130_fd_sc_hd__xnor2_1
XFILLER_50_298 VGND VGND VPWR VPWR sky130_fd_sc_hd__decap_3
X_2918_ net5 VGND VGND VPWR VPWR _0014_ sky130_fd_sc_hd__inv_2
Xhold130 _0315_ VGND VGND VPWR VPWR net135 sky130_fd_sc_hd__dlygate4sd3_1
Xhold185 shift_in\[4\] VGND VGND VPWR VPWR net190 sky130_fd_sc_hd__dlygate4sd3_1
X_2849_ net2 VGND VGND VPWR VPWR _0130_ sky130_fd_sc_hd__inv_2
Xhold141 bit_count\[4\] VGND VGND VPWR VPWR net146 sky130_fd_sc_hd__dlygate4sd3_1
Xhold163 my_divider.state VGND VGND VPWR VPWR net168 sky130_fd_sc_hd__dlygate4sd3_1
Xhold152 my_sum_sub.result\[6\] VGND VGND VPWR VPWR net157 sky130_fd_sc_hd__dlygate4sd3_1
Xhold174 my_sum_sub.result\[10\] VGND VGND VPWR VPWR net179 sky130_fd_sc_hd__dlygate4sd3_1
XFILLER_58_365 VGND VGND VPWR VPWR sky130_fd_sc_hd__decap_3
XFILLER_58_354 VGND VGND VPWR VPWR sky130_fd_sc_hd__decap_3
XFILLER_58_321 VGND VGND VPWR VPWR sky130_fd_sc_hd__decap_3
XTAP_TAPCELL_ROW_56_500 VGND VPWR sky130_fd_sc_hd__tapvpwrvgnd_1
XFILLER_37_55 VGND VGND VPWR VPWR sky130_fd_sc_hd__fill_1
XFILLER_37_44 VGND VGND VPWR VPWR sky130_fd_sc_hd__fill_2
Xhold196 _0265_ VGND VGND VPWR VPWR net201 sky130_fd_sc_hd__dlygate4sd3_1
XTAP_TAPCELL_ROW_5_166 VGND VPWR sky130_fd_sc_hd__tapvpwrvgnd_1
XFILLER_53_43 VGND VGND VPWR VPWR sky130_fd_sc_hd__decap_3
XFILLER_41_221 VGND VGND VPWR VPWR sky130_fd_sc_hd__decap_3
XFILLER_5_111 VGND VGND VPWR VPWR sky130_fd_sc_hd__fill_1
XFILLER_5_155 VGND VGND VPWR VPWR sky130_fd_sc_hd__decap_3
XFILLER_49_321 VGND VGND VPWR VPWR sky130_fd_sc_hd__decap_3
XFILLER_5_188 VGND VGND VPWR VPWR sky130_fd_sc_hd__decap_3
XFILLER_5_199 VGND VGND VPWR VPWR sky130_fd_sc_hd__fill_2
XFILLER_49_343 VGND VGND VPWR VPWR sky130_fd_sc_hd__decap_3
XTAP_TAPCELL_ROW_19_257 VGND VPWR sky130_fd_sc_hd__tapvpwrvgnd_1
XTAP_TAPCELL_ROW_62_547 VGND VPWR sky130_fd_sc_hd__tapvpwrvgnd_1
XTAP_TAPCELL_ROW_62_536 VGND VPWR sky130_fd_sc_hd__tapvpwrvgnd_1
XFILLER_32_276 VGND VGND VPWR VPWR sky130_fd_sc_hd__decap_3
XFILLER_32_232 VGND VGND VPWR VPWR sky130_fd_sc_hd__decap_3
XFILLER_17_284 VGND VGND VPWR VPWR sky130_fd_sc_hd__decap_3
X_2703_ _0977_ _0978_ VGND VGND VPWR VPWR _0979_ sky130_fd_sc_hd__nor2_1
X_2565_ _0820_ _0859_ VGND VGND VPWR VPWR _0864_ sky130_fd_sc_hd__xnor2_2
X_1516_ _1065_ VGND VGND VPWR VPWR _1066_ sky130_fd_sc_hd__inv_2
X_2634_ net10 _0908_ _0931_ _0932_ VGND VGND VPWR VPWR _0933_ sky130_fd_sc_hd__a2bb2o_1
XTAP_TAPCELL_ROW_2_147 VGND VPWR sky130_fd_sc_hd__tapvpwrvgnd_1
X_2496_ _0794_ VGND VGND VPWR VPWR _0795_ sky130_fd_sc_hd__inv_2
X_3117_ clknet_4_0_0_clk _0213_ _0028_ VGND VGND VPWR VPWR shift_in\[6\] sky130_fd_sc_hd__dfrtp_1
XFILLER_55_335 VGND VGND VPWR VPWR sky130_fd_sc_hd__fill_1
X_3048_ clknet_4_13_0_clk net208 _0144_ VGND VGND VPWR VPWR my_sum_sub.al_ma\[7\]
+ sky130_fd_sc_hd__dfrtp_1
XFILLER_23_254 VGND VGND VPWR VPWR sky130_fd_sc_hd__fill_2
XFILLER_2_169 VGND VGND VPWR VPWR sky130_fd_sc_hd__fill_1
XFILLER_61_305 VGND VGND VPWR VPWR sky130_fd_sc_hd__decap_3
XFILLER_58_195 VGND VGND VPWR VPWR sky130_fd_sc_hd__fill_1
XFILLER_58_162 VGND VGND VPWR VPWR sky130_fd_sc_hd__decap_3
XFILLER_46_368 VGND VGND VPWR VPWR sky130_fd_sc_hd__fill_2
XFILLER_46_346 VGND VGND VPWR VPWR sky130_fd_sc_hd__decap_3
XFILLER_46_335 VGND VGND VPWR VPWR sky130_fd_sc_hd__fill_2
XFILLER_61_349 VGND VGND VPWR VPWR sky130_fd_sc_hd__decap_3
XTAP_TAPCELL_ROW_24_293 VGND VPWR sky130_fd_sc_hd__tapvpwrvgnd_1
XFILLER_9_26 VGND VGND VPWR VPWR sky130_fd_sc_hd__decap_3
XTAP_TAPCELL_ROW_16_238 VGND VPWR sky130_fd_sc_hd__tapvpwrvgnd_1
XFILLER_43_6 VGND VGND VPWR VPWR sky130_fd_sc_hd__decap_3
XFILLER_49_151 VGND VGND VPWR VPWR sky130_fd_sc_hd__fill_1
XFILLER_49_140 VGND VGND VPWR VPWR sky130_fd_sc_hd__decap_3
X_2281_ _1055_ _0605_ VGND VGND VPWR VPWR _0607_ sky130_fd_sc_hd__nor2_2
X_2350_ acc_reg\[1\] _0364_ VGND VGND VPWR VPWR _0667_ sky130_fd_sc_hd__and2_1
XFILLER_1_180 VGND VGND VPWR VPWR sky130_fd_sc_hd__fill_2
XFILLER_60_360 VGND VGND VPWR VPWR sky130_fd_sc_hd__decap_3
X_1996_ _1051_ acc_reg\[11\] _0402_ VGND VGND VPWR VPWR _0405_ sky130_fd_sc_hd__o21ai_1
X_2548_ _0827_ _0831_ VGND VGND VPWR VPWR _0847_ sky130_fd_sc_hd__nand2_1
X_2617_ _0889_ _0913_ _0909_ VGND VGND VPWR VPWR _0916_ sky130_fd_sc_hd__o21a_1
XFILLER_55_154 VGND VGND VPWR VPWR sky130_fd_sc_hd__decap_3
XFILLER_55_121 VGND VGND VPWR VPWR sky130_fd_sc_hd__fill_1
XFILLER_28_368 VGND VGND VPWR VPWR sky130_fd_sc_hd__fill_2
XFILLER_28_357 VGND VGND VPWR VPWR sky130_fd_sc_hd__fill_2
XFILLER_28_346 VGND VGND VPWR VPWR sky130_fd_sc_hd__decap_3
X_2479_ _0722_ _0749_ _0723_ VGND VGND VPWR VPWR _0778_ sky130_fd_sc_hd__or3b_1
XFILLER_18_24 VGND VGND VPWR VPWR sky130_fd_sc_hd__decap_3
XFILLER_55_187 VGND VGND VPWR VPWR sky130_fd_sc_hd__decap_3
XFILLER_43_349 VGND VGND VPWR VPWR sky130_fd_sc_hd__fill_1
XTAP_TAPCELL_ROW_38_385 VGND VPWR sky130_fd_sc_hd__tapvpwrvgnd_1
XFILLER_11_202 VGND VGND VPWR VPWR sky130_fd_sc_hd__decap_3
XFILLER_11_235 VGND VGND VPWR VPWR sky130_fd_sc_hd__decap_3
XTAP_TAPCELL_ROW_13_219 VGND VPWR sky130_fd_sc_hd__tapvpwrvgnd_1
XTAP_TAPCELL_ROW_21_274 VGND VPWR sky130_fd_sc_hd__tapvpwrvgnd_1
XFILLER_11_279 VGND VGND VPWR VPWR sky130_fd_sc_hd__fill_1
Xclkload0 clknet_4_1_0_clk VGND VGND VPWR VPWR clkload0/Y sky130_fd_sc_hd__inv_8
XFILLER_59_97 VGND VGND VPWR VPWR sky130_fd_sc_hd__decap_3
XFILLER_59_75 VGND VGND VPWR VPWR sky130_fd_sc_hd__decap_3
XFILLER_59_53 VGND VGND VPWR VPWR sky130_fd_sc_hd__decap_3
XFILLER_61_157 VGND VGND VPWR VPWR sky130_fd_sc_hd__decap_3
XFILLER_61_146 VGND VGND VPWR VPWR sky130_fd_sc_hd__fill_1
XFILLER_61_113 VGND VGND VPWR VPWR sky130_fd_sc_hd__decap_3
XFILLER_61_102 VGND VGND VPWR VPWR sky130_fd_sc_hd__decap_3
XFILLER_46_187 VGND VGND VPWR VPWR sky130_fd_sc_hd__fill_2
XFILLER_46_165 VGND VGND VPWR VPWR sky130_fd_sc_hd__fill_1
XFILLER_34_338 VGND VGND VPWR VPWR sky130_fd_sc_hd__decap_3
XFILLER_61_179 VGND VGND VPWR VPWR sky130_fd_sc_hd__fill_1
X_1781_ _1318_ _1324_ VGND VGND VPWR VPWR _1325_ sky130_fd_sc_hd__nor2_1
X_1850_ my_mul.x2\[1\] my_mul.x2\[0\] acc_reg\[2\] acc_reg\[1\] VGND VGND VPWR VPWR
+ _1394_ sky130_fd_sc_hd__and4_1
X_2333_ _0650_ _0651_ _0604_ VGND VGND VPWR VPWR _0652_ sky130_fd_sc_hd__mux2_1
XFILLER_41_3 VGND VGND VPWR VPWR sky130_fd_sc_hd__decap_3
X_2402_ net21 my_sum_sub.cm_exp\[0\] my_sum_sub.cm_mant\[8\] net17 VGND VGND VPWR
+ VPWR _0701_ sky130_fd_sc_hd__a31o_1
XFILLER_6_283 VGND VGND VPWR VPWR sky130_fd_sc_hd__fill_1
X_2195_ _0514_ _0529_ VGND VGND VPWR VPWR _0530_ sky130_fd_sc_hd__nor2_1
X_2264_ net256 _0592_ net127 VGND VGND VPWR VPWR _0321_ sky130_fd_sc_hd__mux2_1
XFILLER_52_102 VGND VGND VPWR VPWR sky130_fd_sc_hd__fill_2
XFILLER_37_187 VGND VGND VPWR VPWR sky130_fd_sc_hd__decap_3
X_1979_ _1105_ _1147_ VGND VGND VPWR VPWR _0388_ sky130_fd_sc_hd__nor2_1
XFILLER_20_25 VGND VGND VPWR VPWR sky130_fd_sc_hd__decap_3
Xhold45 _0224_ VGND VGND VPWR VPWR net50 sky130_fd_sc_hd__dlygate4sd3_1
Xhold56 _0228_ VGND VGND VPWR VPWR net61 sky130_fd_sc_hd__dlygate4sd3_1
Xhold34 _0237_ VGND VGND VPWR VPWR net39 sky130_fd_sc_hd__dlygate4sd3_1
XFILLER_20_69 VGND VGND VPWR VPWR sky130_fd_sc_hd__decap_3
Xhold23 net318 VGND VGND VPWR VPWR net28 sky130_fd_sc_hd__dlygate4sd3_1
XFILLER_28_165 VGND VGND VPWR VPWR sky130_fd_sc_hd__decap_3
Xhold78 shift_in\[10\] VGND VGND VPWR VPWR net83 sky130_fd_sc_hd__dlygate4sd3_1
Xhold67 my_sum_sub.cm_exp\[4\] VGND VGND VPWR VPWR net72 sky130_fd_sc_hd__dlygate4sd3_1
Xhold89 _0252_ VGND VGND VPWR VPWR net94 sky130_fd_sc_hd__dlygate4sd3_1
XFILLER_16_349 VGND VGND VPWR VPWR sky130_fd_sc_hd__decap_3
XFILLER_61_54 VGND VGND VPWR VPWR sky130_fd_sc_hd__fill_2
XFILLER_61_21 VGND VGND VPWR VPWR sky130_fd_sc_hd__decap_3
XFILLER_51_190 VGND VGND VPWR VPWR sky130_fd_sc_hd__decap_3
XFILLER_43_179 VGND VGND VPWR VPWR sky130_fd_sc_hd__fill_1
XFILLER_6_49 VGND VGND VPWR VPWR sky130_fd_sc_hd__decap_3
XFILLER_59_290 VGND VGND VPWR VPWR sky130_fd_sc_hd__decap_3
X_1902_ _1441_ _1445_ VGND VGND VPWR VPWR _1446_ sky130_fd_sc_hd__nand2_1
XFILLER_34_113 VGND VGND VPWR VPWR sky130_fd_sc_hd__decap_3
X_2951_ net5 VGND VGND VPWR VPWR _0047_ sky130_fd_sc_hd__inv_2
X_1833_ _1361_ _1375_ VGND VGND VPWR VPWR _1377_ sky130_fd_sc_hd__or2_1
X_1764_ _1288_ _1298_ _1306_ VGND VGND VPWR VPWR _1308_ sky130_fd_sc_hd__and3_1
X_2882_ net2 VGND VGND VPWR VPWR _0163_ sky130_fd_sc_hd__inv_2
XFILLER_30_363 VGND VGND VPWR VPWR sky130_fd_sc_hd__fill_1
X_1695_ my_mul.x2\[5\] acc_reg\[2\] _1235_ _1236_ VGND VGND VPWR VPWR _1239_ sky130_fd_sc_hd__a31o_1
X_2316_ my_mul.x2\[5\] _0623_ VGND VGND VPWR VPWR _0637_ sky130_fd_sc_hd__and2_1
XFILLER_57_249 VGND VGND VPWR VPWR sky130_fd_sc_hd__decap_3
X_2178_ my_sum_sub.al_ma\[5\] net131 VGND VGND VPWR VPWR _0513_ sky130_fd_sc_hd__and2b_1
X_2247_ _0546_ _0559_ _0578_ VGND VGND VPWR VPWR _0579_ sky130_fd_sc_hd__o21ai_1
XFILLER_25_113 VGND VGND VPWR VPWR sky130_fd_sc_hd__fill_1
XFILLER_33_190 VGND VGND VPWR VPWR sky130_fd_sc_hd__decap_3
XFILLER_21_363 VGND VGND VPWR VPWR sky130_fd_sc_hd__decap_3
XFILLER_31_57 VGND VGND VPWR VPWR sky130_fd_sc_hd__decap_3
XFILLER_56_43 VGND VGND VPWR VPWR sky130_fd_sc_hd__fill_2
XFILLER_48_205 VGND VGND VPWR VPWR sky130_fd_sc_hd__decap_3
XFILLER_0_278 VGND VGND VPWR VPWR sky130_fd_sc_hd__fill_2
XFILLER_0_256 VGND VGND VPWR VPWR sky130_fd_sc_hd__decap_3
XFILLER_0_234 VGND VGND VPWR VPWR sky130_fd_sc_hd__decap_3
XTAP_TAPCELL_ROW_54_483 VGND VPWR sky130_fd_sc_hd__tapvpwrvgnd_1
XPHY_EDGE_ROW_19_Right_19 VGND VGND VPWR VPWR sky130_fd_sc_hd__decap_3
XFILLER_16_113 VGND VGND VPWR VPWR sky130_fd_sc_hd__fill_2
XFILLER_12_352 VGND VGND VPWR VPWR sky130_fd_sc_hd__decap_3
XPHY_EDGE_ROW_28_Right_28 VGND VGND VPWR VPWR sky130_fd_sc_hd__decap_3
X_3150_ clknet_4_0_0_clk net242 _0061_ VGND VGND VPWR VPWR op_reg\[2\] sky130_fd_sc_hd__dfrtp_2
X_3081_ clknet_4_6_0_clk _0340_ _0177_ VGND VGND VPWR VPWR acc_reg\[2\] sky130_fd_sc_hd__dfrtp_4
XFILLER_47_293 VGND VGND VPWR VPWR sky130_fd_sc_hd__decap_3
X_2101_ _0494_ _0495_ net280 VGND VGND VPWR VPWR _0496_ sky130_fd_sc_hd__o21a_1
XPHY_EDGE_ROW_37_Right_37 VGND VGND VPWR VPWR sky130_fd_sc_hd__decap_3
X_2032_ _0408_ _0436_ _1090_ VGND VGND VPWR VPWR _0437_ sky130_fd_sc_hd__a21oi_1
XFILLER_62_296 VGND VGND VPWR VPWR sky130_fd_sc_hd__decap_3
XFILLER_62_274 VGND VGND VPWR VPWR sky130_fd_sc_hd__decap_3
X_2865_ net2 VGND VGND VPWR VPWR _0146_ sky130_fd_sc_hd__inv_2
X_2934_ net5 VGND VGND VPWR VPWR _0030_ sky130_fd_sc_hd__inv_2
X_1747_ my_mul.x2\[4\] my_mul.x2\[3\] acc_reg\[3\] acc_reg\[2\] VGND VGND VPWR VPWR
+ _1291_ sky130_fd_sc_hd__and4_1
X_1678_ _1209_ _1221_ VGND VGND VPWR VPWR _1222_ sky130_fd_sc_hd__nand2_1
X_1816_ _1358_ _1359_ VGND VGND VPWR VPWR _1360_ sky130_fd_sc_hd__nor2_1
XPHY_EDGE_ROW_46_Right_46 VGND VGND VPWR VPWR sky130_fd_sc_hd__decap_3
Xhold301 acc_reg\[0\] VGND VGND VPWR VPWR net306 sky130_fd_sc_hd__dlygate4sd3_1
Xhold312 my_sum_sub.cm_mant\[0\] VGND VGND VPWR VPWR net317 sky130_fd_sc_hd__dlygate4sd3_1
XFILLER_7_81 VGND VGND VPWR VPWR sky130_fd_sc_hd__fill_1
X_2796_ _1060_ net173 _0499_ _1047_ VGND VGND VPWR VPWR _0010_ sky130_fd_sc_hd__a31o_1
XPHY_EDGE_ROW_55_Right_55 VGND VGND VPWR VPWR sky130_fd_sc_hd__decap_3
XTAP_TAPCELL_ROW_51_464 VGND VPWR sky130_fd_sc_hd__tapvpwrvgnd_1
XFILLER_5_326 VGND VGND VPWR VPWR sky130_fd_sc_hd__decap_3
XFILLER_5_337 VGND VGND VPWR VPWR sky130_fd_sc_hd__decap_3
XTAP_TAPCELL_ROW_8_186 VGND VPWR sky130_fd_sc_hd__tapvpwrvgnd_1
XTAP_TAPCELL_ROW_59_520 VGND VPWR sky130_fd_sc_hd__tapvpwrvgnd_1
XFILLER_29_293 VGND VGND VPWR VPWR sky130_fd_sc_hd__decap_3
XFILLER_44_285 VGND VGND VPWR VPWR sky130_fd_sc_hd__decap_3
XFILLER_44_263 VGND VGND VPWR VPWR sky130_fd_sc_hd__decap_3
X_1601_ net100 acc_reg\[14\] VGND VGND VPWR VPWR _1145_ sky130_fd_sc_hd__or2_1
X_1532_ _1049_ _1073_ _1074_ _1080_ VGND VGND VPWR VPWR _0242_ sky130_fd_sc_hd__a31o_1
X_2581_ _0874_ _0875_ _0877_ _0879_ VGND VGND VPWR VPWR _0880_ sky130_fd_sc_hd__or4b_4
X_2650_ _0948_ VGND VGND VPWR VPWR _0949_ sky130_fd_sc_hd__inv_2
X_3133_ clknet_4_6_0_clk net63 _0044_ VGND VGND VPWR VPWR shift_out\[6\] sky130_fd_sc_hd__dfrtp_1
XFILLER_50_233 VGND VGND VPWR VPWR sky130_fd_sc_hd__decap_3
X_3064_ clknet_4_13_0_clk net265 _0160_ VGND VGND VPWR VPWR my_sum_sub.cm_mant\[4\]
+ sky130_fd_sc_hd__dfrtp_1
X_2015_ _1435_ _1437_ _0373_ _0369_ VGND VGND VPWR VPWR _0422_ sky130_fd_sc_hd__a31oi_1
XFILLER_35_252 VGND VGND VPWR VPWR sky130_fd_sc_hd__decap_3
X_2848_ net2 VGND VGND VPWR VPWR _0129_ sky130_fd_sc_hd__inv_2
X_2917_ net5 VGND VGND VPWR VPWR _0013_ sky130_fd_sc_hd__inv_2
XFILLER_12_26 VGND VGND VPWR VPWR sky130_fd_sc_hd__fill_2
Xhold175 my_mul.x2\[2\] VGND VGND VPWR VPWR net180 sky130_fd_sc_hd__dlygate4sd3_1
Xhold153 my_mul.x2\[0\] VGND VGND VPWR VPWR net158 sky130_fd_sc_hd__dlygate4sd3_1
Xhold164 my_sum_sub.result\[9\] VGND VGND VPWR VPWR net169 sky130_fd_sc_hd__dlygate4sd3_1
Xhold186 my_sum_sub.result\[13\] VGND VGND VPWR VPWR net191 sky130_fd_sc_hd__dlygate4sd3_1
XFILLER_2_307 VGND VGND VPWR VPWR sky130_fd_sc_hd__fill_1
Xhold142 _0243_ VGND VGND VPWR VPWR net147 sky130_fd_sc_hd__dlygate4sd3_1
X_2779_ my_mul.x2\[6\] _0623_ _0973_ net298 VGND VGND VPWR VPWR _0254_ sky130_fd_sc_hd__a31o_1
Xhold197 ss_s1 VGND VGND VPWR VPWR net202 sky130_fd_sc_hd__dlygate4sd3_1
Xhold131 my_divider.divisor_reg\[5\] VGND VGND VPWR VPWR net136 sky130_fd_sc_hd__dlygate4sd3_1
Xhold120 my_sum_sub.result\[14\] VGND VGND VPWR VPWR net125 sky130_fd_sc_hd__dlygate4sd3_1
XFILLER_58_333 VGND VGND VPWR VPWR sky130_fd_sc_hd__decap_3
XTAP_TAPCELL_ROW_56_501 VGND VPWR sky130_fd_sc_hd__tapvpwrvgnd_1
XTAP_TAPCELL_ROW_5_167 VGND VPWR sky130_fd_sc_hd__tapvpwrvgnd_1
XFILLER_53_88 VGND VGND VPWR VPWR sky130_fd_sc_hd__decap_3
XFILLER_53_22 VGND VGND VPWR VPWR sky130_fd_sc_hd__decap_3
XFILLER_41_266 VGND VGND VPWR VPWR sky130_fd_sc_hd__fill_1
XFILLER_41_244 VGND VGND VPWR VPWR sky130_fd_sc_hd__decap_3
XFILLER_26_285 VGND VGND VPWR VPWR sky130_fd_sc_hd__decap_3
XFILLER_5_167 VGND VGND VPWR VPWR sky130_fd_sc_hd__fill_1
XFILLER_49_333 VGND VGND VPWR VPWR sky130_fd_sc_hd__decap_3
XFILLER_1_362 VGND VGND VPWR VPWR sky130_fd_sc_hd__decap_3
XTAP_TAPCELL_ROW_62_537 VGND VPWR sky130_fd_sc_hd__tapvpwrvgnd_1
XFILLER_32_211 VGND VGND VPWR VPWR sky130_fd_sc_hd__decap_3
XTAP_TAPCELL_ROW_19_258 VGND VPWR sky130_fd_sc_hd__tapvpwrvgnd_1
X_2702_ my_divider.remainder_reg\[5\] my_divider.divisor_reg\[5\] VGND VGND VPWR VPWR
+ _0978_ sky130_fd_sc_hd__and2b_1
X_2564_ _0857_ _0862_ VGND VGND VPWR VPWR _0863_ sky130_fd_sc_hd__nor2_1
X_2495_ _0761_ _0787_ VGND VGND VPWR VPWR _0794_ sky130_fd_sc_hd__xor2_1
X_1515_ net30 net87 VGND VGND VPWR VPWR _1065_ sky130_fd_sc_hd__and2b_1
X_2633_ net9 _0905_ _0910_ VGND VGND VPWR VPWR _0932_ sky130_fd_sc_hd__a21oi_1
XFILLER_4_71 VGND VGND VPWR VPWR sky130_fd_sc_hd__decap_3
XTAP_TAPCELL_ROW_2_148 VGND VPWR sky130_fd_sc_hd__tapvpwrvgnd_1
X_3116_ clknet_4_1_0_clk _0212_ _0027_ VGND VGND VPWR VPWR shift_in\[5\] sky130_fd_sc_hd__dfrtp_2
XFILLER_55_369 VGND VGND VPWR VPWR sky130_fd_sc_hd__fill_1
X_3047_ clknet_4_15_0_clk _0306_ _0143_ VGND VGND VPWR VPWR my_sum_sub.al_ma\[6\]
+ sky130_fd_sc_hd__dfrtp_1
XFILLER_23_200 VGND VGND VPWR VPWR sky130_fd_sc_hd__decap_3
XFILLER_23_25 VGND VGND VPWR VPWR sky130_fd_sc_hd__decap_3
XFILLER_58_141 VGND VGND VPWR VPWR sky130_fd_sc_hd__decap_3
XFILLER_61_317 VGND VGND VPWR VPWR sky130_fd_sc_hd__decap_3
XFILLER_58_174 VGND VGND VPWR VPWR sky130_fd_sc_hd__decap_3
XFILLER_0_29 VGND VGND VPWR VPWR sky130_fd_sc_hd__fill_1
XFILLER_14_200 VGND VGND VPWR VPWR sky130_fd_sc_hd__decap_3
XFILLER_14_211 VGND VGND VPWR VPWR sky130_fd_sc_hd__fill_2
XTAP_TAPCELL_ROW_24_294 VGND VPWR sky130_fd_sc_hd__tapvpwrvgnd_1
XTAP_TAPCELL_ROW_16_239 VGND VPWR sky130_fd_sc_hd__tapvpwrvgnd_1
XFILLER_37_347 VGND VGND VPWR VPWR sky130_fd_sc_hd__fill_2
XFILLER_36_6 VGND VGND VPWR VPWR sky130_fd_sc_hd__decap_3
X_2280_ _1055_ _0604_ VGND VGND VPWR VPWR _0606_ sky130_fd_sc_hd__nor2_4
XFILLER_52_339 VGND VGND VPWR VPWR sky130_fd_sc_hd__decap_3
XFILLER_37_369 VGND VGND VPWR VPWR sky130_fd_sc_hd__fill_1
X_1995_ _1105_ _0403_ _1106_ VGND VGND VPWR VPWR _0404_ sky130_fd_sc_hd__o21ba_1
XFILLER_9_281 VGND VGND VPWR VPWR sky130_fd_sc_hd__decap_3
X_2616_ _0883_ _0914_ VGND VGND VPWR VPWR _0915_ sky130_fd_sc_hd__or2_1
X_2547_ _0845_ VGND VGND VPWR VPWR _0846_ sky130_fd_sc_hd__inv_2
X_2478_ _0704_ _0721_ VGND VGND VPWR VPWR _0777_ sky130_fd_sc_hd__nor2_1
XFILLER_55_166 VGND VGND VPWR VPWR sky130_fd_sc_hd__fill_2
XFILLER_34_24 VGND VGND VPWR VPWR sky130_fd_sc_hd__decap_3
XFILLER_11_214 VGND VGND VPWR VPWR sky130_fd_sc_hd__fill_2
XFILLER_11_247 VGND VGND VPWR VPWR sky130_fd_sc_hd__decap_3
Xclkload1 clknet_4_2_0_clk VGND VGND VPWR VPWR clkload1/Y sky130_fd_sc_hd__inv_6
XFILLER_59_21 VGND VGND VPWR VPWR sky130_fd_sc_hd__decap_3
XFILLER_1_3 VGND VGND VPWR VPWR sky130_fd_sc_hd__decap_3
XFILLER_59_87 VGND VGND VPWR VPWR sky130_fd_sc_hd__fill_2
XFILLER_46_122 VGND VGND VPWR VPWR sky130_fd_sc_hd__decap_3
XFILLER_19_325 VGND VGND VPWR VPWR sky130_fd_sc_hd__decap_3
XFILLER_46_155 VGND VGND VPWR VPWR sky130_fd_sc_hd__fill_2
XFILLER_34_306 VGND VGND VPWR VPWR sky130_fd_sc_hd__fill_2
XFILLER_19_369 VGND VGND VPWR VPWR sky130_fd_sc_hd__fill_1
X_1780_ _1262_ _1323_ VGND VGND VPWR VPWR _1324_ sky130_fd_sc_hd__nand2b_1
X_2332_ acc_reg\[3\] _0364_ VGND VGND VPWR VPWR _0651_ sky130_fd_sc_hd__and2_1
X_2401_ net17 net22 my_sum_sub.cm_exp\[0\] my_sum_sub.cm_mant\[8\] VGND VGND VPWR
+ VPWR _0700_ sky130_fd_sc_hd__nand4_1
XFILLER_52_125 VGND VGND VPWR VPWR sky130_fd_sc_hd__decap_3
XFILLER_52_114 VGND VGND VPWR VPWR sky130_fd_sc_hd__decap_3
X_2194_ _0515_ _0528_ _0516_ VGND VGND VPWR VPWR _0529_ sky130_fd_sc_hd__o21bai_1
X_2263_ _0536_ _0591_ VGND VGND VPWR VPWR _0592_ sky130_fd_sc_hd__xnor2_1
XFILLER_37_133 VGND VGND VPWR VPWR sky130_fd_sc_hd__decap_3
XFILLER_37_111 VGND VGND VPWR VPWR sky130_fd_sc_hd__fill_1
XFILLER_60_180 VGND VGND VPWR VPWR sky130_fd_sc_hd__decap_3
XFILLER_40_309 VGND VGND VPWR VPWR sky130_fd_sc_hd__decap_3
X_1978_ _1105_ _1147_ VGND VGND VPWR VPWR _0387_ sky130_fd_sc_hd__and2_1
XFILLER_20_48 VGND VGND VPWR VPWR sky130_fd_sc_hd__decap_3
Xhold57 shift_out\[6\] VGND VGND VPWR VPWR net62 sky130_fd_sc_hd__dlygate4sd3_1
Xhold46 shift_out\[7\] VGND VGND VPWR VPWR net51 sky130_fd_sc_hd__dlygate4sd3_1
Xhold79 _0216_ VGND VGND VPWR VPWR net84 sky130_fd_sc_hd__dlygate4sd3_1
Xhold68 _0333_ VGND VGND VPWR VPWR net73 sky130_fd_sc_hd__dlygate4sd3_1
Xhold35 shift_out\[15\] VGND VGND VPWR VPWR net40 sky130_fd_sc_hd__dlygate4sd3_1
Xhold24 net315 VGND VGND VPWR VPWR net29 sky130_fd_sc_hd__dlygate4sd3_1
XTAP_TAPCELL_ROW_26_301 VGND VPWR sky130_fd_sc_hd__tapvpwrvgnd_1
XFILLER_24_361 VGND VGND VPWR VPWR sky130_fd_sc_hd__decap_3
XFILLER_61_99 VGND VGND VPWR VPWR sky130_fd_sc_hd__decap_3
XFILLER_61_33 VGND VGND VPWR VPWR sky130_fd_sc_hd__fill_2
XFILLER_19_111 VGND VGND VPWR VPWR sky130_fd_sc_hd__fill_1
X_1832_ _1361_ _1375_ VGND VGND VPWR VPWR _1376_ sky130_fd_sc_hd__nand2_1
X_2881_ net2 VGND VGND VPWR VPWR _0162_ sky130_fd_sc_hd__inv_2
X_1901_ _1426_ _1440_ VGND VGND VPWR VPWR _1445_ sky130_fd_sc_hd__nand2_1
XFILLER_42_191 VGND VGND VPWR VPWR sky130_fd_sc_hd__decap_3
XFILLER_34_147 VGND VGND VPWR VPWR sky130_fd_sc_hd__decap_3
XFILLER_34_125 VGND VGND VPWR VPWR sky130_fd_sc_hd__decap_3
X_2950_ net5 VGND VGND VPWR VPWR _0046_ sky130_fd_sc_hd__inv_2
X_1694_ my_mul.x2\[5\] acc_reg\[2\] VGND VGND VPWR VPWR _1238_ sky130_fd_sc_hd__nand2_1
X_1763_ _1298_ _1306_ _1288_ VGND VGND VPWR VPWR _1307_ sky130_fd_sc_hd__a21oi_1
XTAP_TAPCELL_ROW_40_392 VGND VPWR sky130_fd_sc_hd__tapvpwrvgnd_1
XFILLER_57_217 VGND VGND VPWR VPWR sky130_fd_sc_hd__decap_3
X_2246_ _0546_ _0577_ VGND VGND VPWR VPWR _0578_ sky130_fd_sc_hd__nand2_1
X_2315_ acc_reg\[5\] _0364_ _0605_ VGND VGND VPWR VPWR _0636_ sky130_fd_sc_hd__a21o_1
X_2177_ my_sum_sub.al_mb\[6\] my_sum_sub.al_ma\[6\] VGND VGND VPWR VPWR _0512_ sky130_fd_sc_hd__and2b_1
XFILLER_25_169 VGND VGND VPWR VPWR sky130_fd_sc_hd__decap_3
XFILLER_0_246 VGND VGND VPWR VPWR sky130_fd_sc_hd__decap_3
XFILLER_56_88 VGND VGND VPWR VPWR sky130_fd_sc_hd__fill_2
XFILLER_56_77 VGND VGND VPWR VPWR sky130_fd_sc_hd__decap_3
XFILLER_56_55 VGND VGND VPWR VPWR sky130_fd_sc_hd__decap_3
XTAP_TAPCELL_ROW_54_484 VGND VPWR sky130_fd_sc_hd__tapvpwrvgnd_1
XFILLER_8_302 VGND VGND VPWR VPWR sky130_fd_sc_hd__fill_1
XFILLER_8_368 VGND VGND VPWR VPWR sky130_fd_sc_hd__fill_2
X_3080_ clknet_4_6_0_clk _0339_ _0176_ VGND VGND VPWR VPWR acc_reg\[1\] sky130_fd_sc_hd__dfrtp_4
XFILLER_39_228 VGND VGND VPWR VPWR sky130_fd_sc_hd__decap_3
X_2100_ net196 _1088_ _1090_ net34 VGND VGND VPWR VPWR _0495_ sky130_fd_sc_hd__a22o_1
XFILLER_62_253 VGND VGND VPWR VPWR sky130_fd_sc_hd__decap_3
XFILLER_62_231 VGND VGND VPWR VPWR sky130_fd_sc_hd__decap_3
X_2031_ _1119_ _0386_ VGND VGND VPWR VPWR _0436_ sky130_fd_sc_hd__xnor2_1
XFILLER_22_106 VGND VGND VPWR VPWR sky130_fd_sc_hd__fill_2
X_1815_ _1337_ _1340_ _1357_ VGND VGND VPWR VPWR _1359_ sky130_fd_sc_hd__a21oi_1
X_2864_ net2 VGND VGND VPWR VPWR _0145_ sky130_fd_sc_hd__inv_2
X_2933_ net2 VGND VGND VPWR VPWR _0029_ sky130_fd_sc_hd__inv_2
XFILLER_30_194 VGND VGND VPWR VPWR sky130_fd_sc_hd__fill_2
XFILLER_30_172 VGND VGND VPWR VPWR sky130_fd_sc_hd__decap_3
X_2795_ net280 _1043_ _1046_ _1062_ VGND VGND VPWR VPWR _1047_ sky130_fd_sc_hd__a22o_1
X_1746_ my_mul.x2\[3\] acc_reg\[3\] acc_reg\[2\] my_mul.x2\[4\] VGND VGND VPWR VPWR
+ _1290_ sky130_fd_sc_hd__a22oi_1
X_1677_ _1219_ _1220_ _1215_ VGND VGND VPWR VPWR _1221_ sky130_fd_sc_hd__o21ai_1
Xhold302 acc_reg\[1\] VGND VGND VPWR VPWR net307 sky130_fd_sc_hd__dlygate4sd3_1
Xhold313 mosi_s0 VGND VGND VPWR VPWR net318 sky130_fd_sc_hd__dlygate4sd3_1
XFILLER_7_60 VGND VGND VPWR VPWR sky130_fd_sc_hd__fill_1
X_2229_ _0546_ _0547_ _0563_ VGND VGND VPWR VPWR _0564_ sky130_fd_sc_hd__a21oi_1
XFILLER_38_261 VGND VGND VPWR VPWR sky130_fd_sc_hd__decap_3
XFILLER_53_220 VGND VGND VPWR VPWR sky130_fd_sc_hd__fill_1
XTAP_TAPCELL_ROW_51_465 VGND VPWR sky130_fd_sc_hd__tapvpwrvgnd_1
XTAP_TAPCELL_ROW_59_521 VGND VPWR sky130_fd_sc_hd__tapvpwrvgnd_1
XTAP_TAPCELL_ROW_8_187 VGND VPWR sky130_fd_sc_hd__tapvpwrvgnd_1
XTAP_TAPCELL_ROW_42_410 VGND VPWR sky130_fd_sc_hd__tapvpwrvgnd_1
XFILLER_16_80 VGND VGND VPWR VPWR sky130_fd_sc_hd__decap_3
X_1600_ my_mul.x2\[12\] acc_reg\[12\] _1107_ _1143_ VGND VGND VPWR VPWR _1144_ sky130_fd_sc_hd__a31oi_1
X_1531_ _1049_ _1079_ VGND VGND VPWR VPWR _1080_ sky130_fd_sc_hd__nor2_1
X_2580_ _0867_ _0844_ _0870_ _0842_ VGND VGND VPWR VPWR _0879_ sky130_fd_sc_hd__a211oi_2
X_3063_ clknet_4_15_0_clk _0322_ _0159_ VGND VGND VPWR VPWR my_sum_sub.cm_mant\[3\]
+ sky130_fd_sc_hd__dfrtp_1
X_3132_ clknet_4_7_0_clk net61 _0043_ VGND VGND VPWR VPWR shift_out\[5\] sky130_fd_sc_hd__dfrtp_1
X_2014_ _1437_ _0373_ _0420_ VGND VGND VPWR VPWR _0421_ sky130_fd_sc_hd__a21o_1
XFILLER_35_231 VGND VGND VPWR VPWR sky130_fd_sc_hd__decap_3
X_2847_ net2 VGND VGND VPWR VPWR _0128_ sky130_fd_sc_hd__inv_2
X_2778_ _1059_ _0973_ VGND VGND VPWR VPWR _1039_ sky130_fd_sc_hd__nor2_1
X_2916_ net2 VGND VGND VPWR VPWR _0012_ sky130_fd_sc_hd__inv_2
Xhold110 div_quotient\[2\] VGND VGND VPWR VPWR net115 sky130_fd_sc_hd__dlygate4sd3_1
X_1729_ _1268_ _1269_ _1272_ VGND VGND VPWR VPWR _1273_ sky130_fd_sc_hd__or3_1
XFILLER_58_312 VGND VGND VPWR VPWR sky130_fd_sc_hd__decap_3
XFILLER_58_301 VGND VGND VPWR VPWR sky130_fd_sc_hd__decap_3
Xhold143 my_sum_sub.cm_sign VGND VGND VPWR VPWR net148 sky130_fd_sc_hd__dlygate4sd3_1
Xhold187 _0289_ VGND VGND VPWR VPWR net192 sky130_fd_sc_hd__dlygate4sd3_1
Xhold176 my_sum_sub.cm_exp\[7\] VGND VGND VPWR VPWR net181 sky130_fd_sc_hd__dlygate4sd3_1
Xhold165 my_sum_sub.result\[8\] VGND VGND VPWR VPWR net170 sky130_fd_sc_hd__dlygate4sd3_1
Xhold132 _0253_ VGND VGND VPWR VPWR net137 sky130_fd_sc_hd__dlygate4sd3_1
Xhold198 _0009_ VGND VGND VPWR VPWR net203 sky130_fd_sc_hd__dlygate4sd3_1
Xhold154 my_sum_sub.state\[0\] VGND VGND VPWR VPWR net159 sky130_fd_sc_hd__dlygate4sd3_1
Xhold121 _0290_ VGND VGND VPWR VPWR net126 sky130_fd_sc_hd__dlygate4sd3_1
XFILLER_58_345 VGND VGND VPWR VPWR sky130_fd_sc_hd__decap_3
XTAP_TAPCELL_ROW_56_502 VGND VPWR sky130_fd_sc_hd__tapvpwrvgnd_1
XFILLER_37_35 VGND VGND VPWR VPWR sky130_fd_sc_hd__decap_3
XFILLER_26_253 VGND VGND VPWR VPWR sky130_fd_sc_hd__fill_1
XTAP_TAPCELL_ROW_5_168 VGND VPWR sky130_fd_sc_hd__tapvpwrvgnd_1
XFILLER_53_67 VGND VGND VPWR VPWR sky130_fd_sc_hd__decap_3
XFILLER_53_12 VGND VGND VPWR VPWR sky130_fd_sc_hd__fill_2
XFILLER_41_278 VGND VGND VPWR VPWR sky130_fd_sc_hd__fill_2
XFILLER_49_312 VGND VGND VPWR VPWR sky130_fd_sc_hd__decap_3
XFILLER_49_301 VGND VGND VPWR VPWR sky130_fd_sc_hd__decap_3
XTAP_TAPCELL_ROW_62_538 VGND VPWR sky130_fd_sc_hd__tapvpwrvgnd_1
XTAP_TAPCELL_ROW_19_259 VGND VPWR sky130_fd_sc_hd__tapvpwrvgnd_1
XFILLER_17_275 VGND VGND VPWR VPWR sky130_fd_sc_hd__decap_3
XFILLER_17_297 VGND VGND VPWR VPWR sky130_fd_sc_hd__decap_3
X_2701_ my_divider.divisor_reg\[5\] net200 VGND VGND VPWR VPWR _0977_ sky130_fd_sc_hd__and2b_1
X_2632_ _0889_ _0913_ _0930_ _0867_ VGND VGND VPWR VPWR _0931_ sky130_fd_sc_hd__o22ai_1
X_2563_ _0815_ _0839_ VGND VGND VPWR VPWR _0862_ sky130_fd_sc_hd__xnor2_2
X_2494_ net7 _0791_ VGND VGND VPWR VPWR _0793_ sky130_fd_sc_hd__xor2_2
X_1514_ state\[3\] state\[5\] VGND VGND VPWR VPWR _1064_ sky130_fd_sc_hd__or2_4
X_3046_ clknet_4_15_0_clk net212 _0142_ VGND VGND VPWR VPWR my_sum_sub.al_ma\[5\]
+ sky130_fd_sc_hd__dfrtp_1
X_3115_ clknet_4_7_0_clk _0211_ _0026_ VGND VGND VPWR VPWR shift_in\[4\] sky130_fd_sc_hd__dfrtp_2
XTAP_TAPCELL_ROW_2_149 VGND VPWR sky130_fd_sc_hd__tapvpwrvgnd_1
XFILLER_23_223 VGND VGND VPWR VPWR sky130_fd_sc_hd__fill_1
XFILLER_58_120 VGND VGND VPWR VPWR sky130_fd_sc_hd__decap_3
XFILLER_48_78 VGND VGND VPWR VPWR sky130_fd_sc_hd__decap_3
XFILLER_48_12 VGND VGND VPWR VPWR sky130_fd_sc_hd__decap_3
XFILLER_61_329 VGND VGND VPWR VPWR sky130_fd_sc_hd__decap_3
XFILLER_58_197 VGND VGND VPWR VPWR sky130_fd_sc_hd__decap_3
XFILLER_46_326 VGND VGND VPWR VPWR sky130_fd_sc_hd__decap_3
XFILLER_0_19 VGND VGND VPWR VPWR sky130_fd_sc_hd__decap_3
XFILLER_14_234 VGND VGND VPWR VPWR sky130_fd_sc_hd__fill_1
XFILLER_14_245 VGND VGND VPWR VPWR sky130_fd_sc_hd__decap_3
XFILLER_13_81 VGND VGND VPWR VPWR sky130_fd_sc_hd__fill_1
XFILLER_50_9 VGND VGND VPWR VPWR sky130_fd_sc_hd__fill_1
XFILLER_60_351 VGND VGND VPWR VPWR sky130_fd_sc_hd__decap_3
X_1994_ _1112_ _0402_ _0401_ VGND VGND VPWR VPWR _0403_ sky130_fd_sc_hd__o21a_1
X_2615_ _0880_ _0890_ _0904_ _0888_ VGND VGND VPWR VPWR _0914_ sky130_fd_sc_hd__o211a_1
X_2546_ _0842_ _0843_ VGND VGND VPWR VPWR _0845_ sky130_fd_sc_hd__or2_1
X_2477_ _0757_ _0758_ _0771_ _0774_ VGND VGND VPWR VPWR _0776_ sky130_fd_sc_hd__a211o_1
XFILLER_55_178 VGND VGND VPWR VPWR sky130_fd_sc_hd__decap_3
XFILLER_55_145 VGND VGND VPWR VPWR sky130_fd_sc_hd__decap_3
XFILLER_55_134 VGND VGND VPWR VPWR sky130_fd_sc_hd__decap_3
X_3029_ clknet_4_11_0_clk net162 _0125_ VGND VGND VPWR VPWR my_sum_sub.result\[12\]
+ sky130_fd_sc_hd__dfrtp_1
XFILLER_50_57 VGND VGND VPWR VPWR sky130_fd_sc_hd__decap_3
XFILLER_50_35 VGND VGND VPWR VPWR sky130_fd_sc_hd__decap_3
XFILLER_11_259 VGND VGND VPWR VPWR sky130_fd_sc_hd__fill_2
Xclkload2 clknet_4_3_0_clk VGND VGND VPWR VPWR clkload2/Y sky130_fd_sc_hd__inv_12
XFILLER_59_66 VGND VGND VPWR VPWR sky130_fd_sc_hd__decap_3
XFILLER_59_44 VGND VGND VPWR VPWR sky130_fd_sc_hd__decap_3
XFILLER_50_79 VGND VGND VPWR VPWR sky130_fd_sc_hd__decap_3
XTAP_TAPCELL_ROW_29_321 VGND VPWR sky130_fd_sc_hd__tapvpwrvgnd_1
XFILLER_46_178 VGND VGND VPWR VPWR sky130_fd_sc_hd__decap_3
XTAP_TAPCELL_ROW_12_210 VGND VPWR sky130_fd_sc_hd__tapvpwrvgnd_1
X_2400_ net16 my_sum_sub.cm_exp\[1\] my_sum_sub.cm_exp\[0\] my_sum_sub.cm_mant\[8\]
+ VGND VGND VPWR VPWR _0699_ sky130_fd_sc_hd__and4_1
X_2331_ my_mul.x2\[3\] _0623_ VGND VGND VPWR VPWR _0650_ sky130_fd_sc_hd__and2_1
X_2262_ _0546_ _0555_ _0590_ VGND VGND VPWR VPWR _0591_ sky130_fd_sc_hd__o21ai_1
XFILLER_52_137 VGND VGND VPWR VPWR sky130_fd_sc_hd__decap_3
X_2193_ _0517_ _0527_ _0519_ VGND VGND VPWR VPWR _0528_ sky130_fd_sc_hd__a21o_1
XFILLER_37_167 VGND VGND VPWR VPWR sky130_fd_sc_hd__fill_1
XFILLER_37_145 VGND VGND VPWR VPWR sky130_fd_sc_hd__decap_3
XFILLER_60_192 VGND VGND VPWR VPWR sky130_fd_sc_hd__decap_3
X_1977_ _1130_ _0385_ _1128_ VGND VGND VPWR VPWR _0386_ sky130_fd_sc_hd__a21oi_1
XFILLER_20_16 VGND VGND VPWR VPWR sky130_fd_sc_hd__decap_3
X_2529_ _0800_ _0826_ VGND VGND VPWR VPWR _0828_ sky130_fd_sc_hd__or2_2
Xhold58 _0229_ VGND VGND VPWR VPWR net63 sky130_fd_sc_hd__dlygate4sd3_1
Xhold47 _0230_ VGND VGND VPWR VPWR net52 sky130_fd_sc_hd__dlygate4sd3_1
XFILLER_29_47 VGND VGND VPWR VPWR sky130_fd_sc_hd__fill_1
XFILLER_28_134 VGND VGND VPWR VPWR sky130_fd_sc_hd__fill_2
Xhold36 _0238_ VGND VGND VPWR VPWR net41 sky130_fd_sc_hd__dlygate4sd3_1
Xhold69 my_divider.divisor_reg\[3\] VGND VGND VPWR VPWR net74 sky130_fd_sc_hd__dlygate4sd3_1
Xhold25 sclk_s0 VGND VGND VPWR VPWR net30 sky130_fd_sc_hd__dlygate4sd3_1
XFILLER_61_12 VGND VGND VPWR VPWR sky130_fd_sc_hd__decap_3
XFILLER_51_181 VGND VGND VPWR VPWR sky130_fd_sc_hd__decap_3
XFILLER_45_57 VGND VGND VPWR VPWR sky130_fd_sc_hd__decap_3
XFILLER_45_35 VGND VGND VPWR VPWR sky130_fd_sc_hd__decap_3
XFILLER_43_104 VGND VGND VPWR VPWR sky130_fd_sc_hd__decap_3
XTAP_TAPCELL_ROW_26_302 VGND VPWR sky130_fd_sc_hd__tapvpwrvgnd_1
XFILLER_16_307 VGND VGND VPWR VPWR sky130_fd_sc_hd__fill_1
XFILLER_16_318 VGND VGND VPWR VPWR sky130_fd_sc_hd__decap_3
XFILLER_3_277 VGND VGND VPWR VPWR sky130_fd_sc_hd__decap_3
XFILLER_59_281 VGND VGND VPWR VPWR sky130_fd_sc_hd__decap_3
XFILLER_19_178 VGND VGND VPWR VPWR sky130_fd_sc_hd__fill_1
XFILLER_19_167 VGND VGND VPWR VPWR sky130_fd_sc_hd__fill_1
XFILLER_19_156 VGND VGND VPWR VPWR sky130_fd_sc_hd__fill_2
X_1831_ _1373_ _1374_ _1372_ VGND VGND VPWR VPWR _1375_ sky130_fd_sc_hd__a21o_1
X_2880_ net2 VGND VGND VPWR VPWR _0161_ sky130_fd_sc_hd__inv_2
X_1900_ _1441_ _1442_ _1443_ _1427_ VGND VGND VPWR VPWR _1444_ sky130_fd_sc_hd__a31o_1
XFILLER_30_365 VGND VGND VPWR VPWR sky130_fd_sc_hd__decap_3
XFILLER_30_343 VGND VGND VPWR VPWR sky130_fd_sc_hd__fill_2
XFILLER_15_340 VGND VGND VPWR VPWR sky130_fd_sc_hd__fill_2
X_1693_ my_mul.x2\[6\] acc_reg\[1\] acc_reg\[0\] VGND VGND VPWR VPWR _1237_ sky130_fd_sc_hd__nand3_1
X_1762_ _1299_ _1305_ VGND VGND VPWR VPWR _1306_ sky130_fd_sc_hd__or2_1
XTAP_TAPCELL_ROW_40_393 VGND VPWR sky130_fd_sc_hd__tapvpwrvgnd_1
X_2176_ my_sum_sub.al_ma\[6\] my_sum_sub.al_mb\[6\] VGND VGND VPWR VPWR _0511_ sky130_fd_sc_hd__and2b_1
X_2314_ net237 _0635_ my_sum_sub.state\[2\] VGND VGND VPWR VPWR _0314_ sky130_fd_sc_hd__mux2_1
X_2245_ my_sum_sub.al_b_larger _0567_ _0576_ VGND VGND VPWR VPWR _0577_ sky130_fd_sc_hd__o21ai_1
XFILLER_40_129 VGND VGND VPWR VPWR sky130_fd_sc_hd__fill_2
XFILLER_25_104 VGND VGND VPWR VPWR sky130_fd_sc_hd__fill_1
XPHY_EDGE_ROW_1_Right_1 VGND VGND VPWR VPWR sky130_fd_sc_hd__decap_3
XFILLER_0_269 VGND VGND VPWR VPWR sky130_fd_sc_hd__decap_3
XFILLER_0_225 VGND VGND VPWR VPWR sky130_fd_sc_hd__decap_3
XFILLER_56_240 VGND VGND VPWR VPWR sky130_fd_sc_hd__decap_3
XFILLER_56_67 VGND VGND VPWR VPWR sky130_fd_sc_hd__decap_3
XFILLER_56_34 VGND VGND VPWR VPWR sky130_fd_sc_hd__decap_3
XFILLER_48_229 VGND VGND VPWR VPWR sky130_fd_sc_hd__decap_3
XTAP_TAPCELL_ROW_54_485 VGND VPWR sky130_fd_sc_hd__tapvpwrvgnd_1
XFILLER_24_192 VGND VGND VPWR VPWR sky130_fd_sc_hd__decap_3
XFILLER_12_365 VGND VGND VPWR VPWR sky130_fd_sc_hd__decap_3
XFILLER_39_207 VGND VGND VPWR VPWR sky130_fd_sc_hd__fill_2
X_2030_ _1444_ _0380_ VGND VGND VPWR VPWR _0435_ sky130_fd_sc_hd__and2_1
XFILLER_11_6 VGND VGND VPWR VPWR sky130_fd_sc_hd__decap_3
XFILLER_62_287 VGND VGND VPWR VPWR sky130_fd_sc_hd__decap_3
XFILLER_62_265 VGND VGND VPWR VPWR sky130_fd_sc_hd__decap_3
XFILLER_62_243 VGND VGND VPWR VPWR sky130_fd_sc_hd__decap_3
XFILLER_47_284 VGND VGND VPWR VPWR sky130_fd_sc_hd__decap_3
XTAP_TAPCELL_ROW_45_430 VGND VPWR sky130_fd_sc_hd__tapvpwrvgnd_1
X_2932_ net2 VGND VGND VPWR VPWR _0028_ sky130_fd_sc_hd__inv_2
X_1745_ _1270_ _1272_ VGND VGND VPWR VPWR _1289_ sky130_fd_sc_hd__xnor2_1
X_1814_ _1337_ _1340_ _1357_ VGND VGND VPWR VPWR _1358_ sky130_fd_sc_hd__and3_1
X_2863_ net2 VGND VGND VPWR VPWR _0144_ sky130_fd_sc_hd__inv_2
XFILLER_30_184 VGND VGND VPWR VPWR sky130_fd_sc_hd__fill_1
X_2794_ _1045_ VGND VGND VPWR VPWR _1046_ sky130_fd_sc_hd__inv_2
X_1676_ _1210_ _1214_ VGND VGND VPWR VPWR _1220_ sky130_fd_sc_hd__xnor2_1
Xhold303 acc_reg\[6\] VGND VGND VPWR VPWR net308 sky130_fd_sc_hd__dlygate4sd3_1
XPHY_EDGE_ROW_15_Left_78 VGND VGND VPWR VPWR sky130_fd_sc_hd__decap_3
X_2228_ _0541_ _0561_ _0562_ VGND VGND VPWR VPWR _0563_ sky130_fd_sc_hd__a21oi_1
X_2159_ net309 _0486_ _0504_ VGND VGND VPWR VPWR _0340_ sky130_fd_sc_hd__mux2_1
XFILLER_26_26 VGND VGND VPWR VPWR sky130_fd_sc_hd__fill_2
XTAP_TAPCELL_ROW_51_466 VGND VPWR sky130_fd_sc_hd__tapvpwrvgnd_1
XTAP_TAPCELL_ROW_8_188 VGND VPWR sky130_fd_sc_hd__tapvpwrvgnd_1
XFILLER_44_276 VGND VGND VPWR VPWR sky130_fd_sc_hd__decap_3
XFILLER_44_221 VGND VGND VPWR VPWR sky130_fd_sc_hd__decap_3
XTAP_TAPCELL_ROW_42_411 VGND VPWR sky130_fd_sc_hd__tapvpwrvgnd_1
XFILLER_59_6 VGND VGND VPWR VPWR sky130_fd_sc_hd__decap_3
X_1530_ _1072_ _1074_ _1069_ VGND VGND VPWR VPWR _1079_ sky130_fd_sc_hd__o21a_1
XFILLER_4_361 VGND VGND VPWR VPWR sky130_fd_sc_hd__decap_3
X_3062_ clknet_4_13_0_clk _0321_ _0158_ VGND VGND VPWR VPWR my_sum_sub.cm_mant\[2\]
+ sky130_fd_sc_hd__dfrtp_1
X_3131_ clknet_4_7_0_clk net45 _0042_ VGND VGND VPWR VPWR shift_out\[4\] sky130_fd_sc_hd__dfrtp_1
X_2013_ _1435_ _0375_ VGND VGND VPWR VPWR _0420_ sky130_fd_sc_hd__xnor2_1
XFILLER_35_210 VGND VGND VPWR VPWR sky130_fd_sc_hd__decap_3
X_2915_ net5 VGND VGND VPWR VPWR _0011_ sky130_fd_sc_hd__inv_2
X_1728_ _1235_ _1238_ _1271_ VGND VGND VPWR VPWR _1272_ sky130_fd_sc_hd__o21ba_1
Xhold122 my_sum_sub.state\[1\] VGND VGND VPWR VPWR net127 sky130_fd_sc_hd__dlygate4sd3_1
Xhold100 my_mul.x2\[11\] VGND VGND VPWR VPWR net105 sky130_fd_sc_hd__dlygate4sd3_1
Xhold144 _0291_ VGND VGND VPWR VPWR net149 sky130_fd_sc_hd__dlygate4sd3_1
Xhold133 my_divider.remainder_reg\[1\] VGND VGND VPWR VPWR net138 sky130_fd_sc_hd__dlygate4sd3_1
X_2777_ net101 _0623_ _0973_ VGND VGND VPWR VPWR _0255_ sky130_fd_sc_hd__mux2_1
Xhold111 _0272_ VGND VGND VPWR VPWR net116 sky130_fd_sc_hd__dlygate4sd3_1
X_2846_ net2 VGND VGND VPWR VPWR _0127_ sky130_fd_sc_hd__inv_2
XFILLER_58_357 VGND VGND VPWR VPWR sky130_fd_sc_hd__decap_3
XFILLER_58_324 VGND VGND VPWR VPWR sky130_fd_sc_hd__decap_3
X_1659_ _1201_ _1202_ VGND VGND VPWR VPWR _1203_ sky130_fd_sc_hd__or2_1
Xhold166 shift_in\[3\] VGND VGND VPWR VPWR net171 sky130_fd_sc_hd__dlygate4sd3_1
XTAP_TAPCELL_ROW_5_169 VGND VPWR sky130_fd_sc_hd__tapvpwrvgnd_1
Xhold199 net4 VGND VGND VPWR VPWR net204 sky130_fd_sc_hd__dlygate4sd3_1
Xhold177 state\[1\] VGND VGND VPWR VPWR net182 sky130_fd_sc_hd__dlygate4sd3_1
Xhold155 _0006_ VGND VGND VPWR VPWR net160 sky130_fd_sc_hd__dlygate4sd3_1
Xhold188 my_sum_sub.result\[7\] VGND VGND VPWR VPWR net193 sky130_fd_sc_hd__dlygate4sd3_1
XFILLER_58_368 VGND VGND VPWR VPWR sky130_fd_sc_hd__fill_2
XFILLER_53_46 VGND VGND VPWR VPWR sky130_fd_sc_hd__decap_3
XFILLER_41_235 VGND VGND VPWR VPWR sky130_fd_sc_hd__decap_3
XFILLER_1_353 VGND VGND VPWR VPWR sky130_fd_sc_hd__decap_3
XFILLER_5_169 VGND VGND VPWR VPWR sky130_fd_sc_hd__decap_3
XFILLER_49_346 VGND VGND VPWR VPWR sky130_fd_sc_hd__decap_3
XFILLER_49_324 VGND VGND VPWR VPWR sky130_fd_sc_hd__decap_3
XTAP_TAPCELL_ROW_62_539 VGND VPWR sky130_fd_sc_hd__tapvpwrvgnd_1
XFILLER_32_235 VGND VGND VPWR VPWR sky130_fd_sc_hd__fill_2
XFILLER_32_202 VGND VGND VPWR VPWR sky130_fd_sc_hd__decap_3
XFILLER_57_3 VGND VGND VPWR VPWR sky130_fd_sc_hd__decap_3
X_2562_ _0814_ _0860_ _0840_ VGND VGND VPWR VPWR _0861_ sky130_fd_sc_hd__a21bo_2
X_2700_ my_divider.remainder_reg\[6\] my_divider.divisor_reg\[6\] VGND VGND VPWR VPWR
+ _0976_ sky130_fd_sc_hd__xnor2_1
X_2631_ _0857_ _0862_ _0864_ _0881_ _0861_ VGND VGND VPWR VPWR _0930_ sky130_fd_sc_hd__o41a_1
X_1513_ state\[3\] state\[5\] VGND VGND VPWR VPWR _1063_ sky130_fd_sc_hd__nor2_1
X_2493_ _0752_ _0791_ VGND VGND VPWR VPWR _0792_ sky130_fd_sc_hd__and2b_1
X_3045_ clknet_4_13_0_clk net210 _0141_ VGND VGND VPWR VPWR my_sum_sub.al_ma\[4\]
+ sky130_fd_sc_hd__dfrtp_1
X_3114_ clknet_4_5_0_clk _0210_ _0025_ VGND VGND VPWR VPWR shift_in\[3\] sky130_fd_sc_hd__dfrtp_1
X_2829_ net5 VGND VGND VPWR VPWR _0110_ sky130_fd_sc_hd__inv_2
XFILLER_58_165 VGND VGND VPWR VPWR sky130_fd_sc_hd__decap_3
XFILLER_58_132 VGND VGND VPWR VPWR sky130_fd_sc_hd__decap_3
XFILLER_46_349 VGND VGND VPWR VPWR sky130_fd_sc_hd__decap_3
XFILLER_46_305 VGND VGND VPWR VPWR sky130_fd_sc_hd__decap_3
XPHY_EDGE_ROW_45_Left_108 VGND VGND VPWR VPWR sky130_fd_sc_hd__decap_3
XPHY_EDGE_ROW_18_Left_81 VGND VGND VPWR VPWR sky130_fd_sc_hd__decap_3
XFILLER_61_308 VGND VGND VPWR VPWR sky130_fd_sc_hd__decap_3
XPHY_EDGE_ROW_54_Left_117 VGND VGND VPWR VPWR sky130_fd_sc_hd__decap_3
XFILLER_9_29 VGND VGND VPWR VPWR sky130_fd_sc_hd__fill_2
XFILLER_43_9 VGND VGND VPWR VPWR sky130_fd_sc_hd__decap_3
XFILLER_49_165 VGND VGND VPWR VPWR sky130_fd_sc_hd__decap_3
XFILLER_60_363 VGND VGND VPWR VPWR sky130_fd_sc_hd__fill_1
XFILLER_60_330 VGND VGND VPWR VPWR sky130_fd_sc_hd__decap_3
X_1993_ _1137_ _0396_ VGND VGND VPWR VPWR _0402_ sky130_fd_sc_hd__or2_1
XFILLER_20_238 VGND VGND VPWR VPWR sky130_fd_sc_hd__decap_3
XTAP_TAPCELL_ROW_15_230 VGND VPWR sky130_fd_sc_hd__tapvpwrvgnd_1
X_2545_ _0829_ _0840_ VGND VGND VPWR VPWR _0844_ sky130_fd_sc_hd__xor2_1
X_2614_ _0880_ _0890_ _0904_ VGND VGND VPWR VPWR _0913_ sky130_fd_sc_hd__o21ai_2
X_2476_ _0771_ _0774_ VGND VGND VPWR VPWR _0775_ sky130_fd_sc_hd__nor2_1
XFILLER_18_27 VGND VGND VPWR VPWR sky130_fd_sc_hd__fill_1
XFILLER_55_157 VGND VGND VPWR VPWR sky130_fd_sc_hd__decap_3
XFILLER_51_341 VGND VGND VPWR VPWR sky130_fd_sc_hd__fill_1
XFILLER_11_205 VGND VGND VPWR VPWR sky130_fd_sc_hd__decap_3
X_3028_ clknet_4_9_0_clk net151 _0124_ VGND VGND VPWR VPWR my_sum_sub.result\[11\]
+ sky130_fd_sc_hd__dfrtp_1
Xclkload3 clknet_4_4_0_clk VGND VGND VPWR VPWR clkload3/Y sky130_fd_sc_hd__inv_12
XFILLER_11_238 VGND VGND VPWR VPWR sky130_fd_sc_hd__decap_3
XFILLER_59_78 VGND VGND VPWR VPWR sky130_fd_sc_hd__decap_3
XFILLER_59_12 VGND VGND VPWR VPWR sky130_fd_sc_hd__decap_3
XFILLER_61_116 VGND VGND VPWR VPWR sky130_fd_sc_hd__decap_3
XFILLER_46_146 VGND VGND VPWR VPWR sky130_fd_sc_hd__fill_2
XFILLER_46_135 VGND VGND VPWR VPWR sky130_fd_sc_hd__decap_3
XTAP_TAPCELL_ROW_29_322 VGND VPWR sky130_fd_sc_hd__tapvpwrvgnd_1
XPHY_EDGE_ROW_3_Left_66 VGND VGND VPWR VPWR sky130_fd_sc_hd__decap_3
XFILLER_61_127 VGND VGND VPWR VPWR sky130_fd_sc_hd__decap_3
XFILLER_42_363 VGND VGND VPWR VPWR sky130_fd_sc_hd__fill_1
XFILLER_42_352 VGND VGND VPWR VPWR sky130_fd_sc_hd__fill_2
XFILLER_24_81 VGND VGND VPWR VPWR sky130_fd_sc_hd__decap_3
XTAP_TAPCELL_ROW_12_211 VGND VPWR sky130_fd_sc_hd__tapvpwrvgnd_1
XFILLER_41_6 VGND VGND VPWR VPWR sky130_fd_sc_hd__decap_3
XFILLER_6_231 VGND VGND VPWR VPWR sky130_fd_sc_hd__fill_1
XFILLER_10_282 VGND VGND VPWR VPWR sky130_fd_sc_hd__decap_3
X_2330_ my_sum_sub.state\[2\] net129 _0649_ VGND VGND VPWR VPWR _0312_ sky130_fd_sc_hd__o21a_1
X_2192_ _0520_ _0526_ _0521_ VGND VGND VPWR VPWR _0527_ sky130_fd_sc_hd__o21ba_1
X_2261_ my_sum_sub.al_b_larger _0526_ _0589_ VGND VGND VPWR VPWR _0590_ sky130_fd_sc_hd__a21o_1
XFILLER_37_124 VGND VGND VPWR VPWR sky130_fd_sc_hd__decap_3
XFILLER_37_113 VGND VGND VPWR VPWR sky130_fd_sc_hd__fill_1
XFILLER_33_330 VGND VGND VPWR VPWR sky130_fd_sc_hd__fill_1
X_1976_ _1124_ _0384_ _1125_ VGND VGND VPWR VPWR _0385_ sky130_fd_sc_hd__o21ai_1
X_2528_ _0800_ _0826_ VGND VGND VPWR VPWR _0827_ sky130_fd_sc_hd__nor2_1
Xhold37 shift_out\[8\] VGND VGND VPWR VPWR net42 sky130_fd_sc_hd__dlygate4sd3_1
XFILLER_28_168 VGND VGND VPWR VPWR sky130_fd_sc_hd__decap_3
XTAP_TAPCELL_ROW_26_303 VGND VPWR sky130_fd_sc_hd__tapvpwrvgnd_1
Xhold59 shift_out\[13\] VGND VGND VPWR VPWR net64 sky130_fd_sc_hd__dlygate4sd3_1
Xhold26 mosi_s1 VGND VGND VPWR VPWR net31 sky130_fd_sc_hd__dlygate4sd3_1
Xhold48 my_sum_sub.result\[5\] VGND VGND VPWR VPWR net53 sky130_fd_sc_hd__dlygate4sd3_1
X_2459_ _0746_ _0753_ _0755_ VGND VGND VPWR VPWR _0758_ sky130_fd_sc_hd__nand3_1
XFILLER_61_57 VGND VGND VPWR VPWR sky130_fd_sc_hd__fill_1
XFILLER_61_24 VGND VGND VPWR VPWR sky130_fd_sc_hd__decap_3
XFILLER_51_193 VGND VGND VPWR VPWR sky130_fd_sc_hd__decap_3
XFILLER_51_160 VGND VGND VPWR VPWR sky130_fd_sc_hd__fill_1
XFILLER_3_212 VGND VGND VPWR VPWR sky130_fd_sc_hd__decap_3
XFILLER_59_260 VGND VGND VPWR VPWR sky130_fd_sc_hd__decap_3
XFILLER_10_83 VGND VGND VPWR VPWR sky130_fd_sc_hd__fill_1
XFILLER_59_293 VGND VGND VPWR VPWR sky130_fd_sc_hd__decap_3
XFILLER_34_116 VGND VGND VPWR VPWR sky130_fd_sc_hd__fill_1
XFILLER_15_330 VGND VGND VPWR VPWR sky130_fd_sc_hd__decap_3
X_1830_ _1362_ _1371_ VGND VGND VPWR VPWR _1374_ sky130_fd_sc_hd__xor2_1
X_1761_ _1303_ _1304_ VGND VGND VPWR VPWR _1305_ sky130_fd_sc_hd__or2_1
XFILLER_51_90 VGND VGND VPWR VPWR sky130_fd_sc_hd__decap_3
XFILLER_42_171 VGND VGND VPWR VPWR sky130_fd_sc_hd__decap_3
XFILLER_42_160 VGND VGND VPWR VPWR sky130_fd_sc_hd__fill_2
XTAP_TAPCELL_ROW_40_394 VGND VPWR sky130_fd_sc_hd__tapvpwrvgnd_1
X_1692_ my_mul.x2\[6\] acc_reg\[1\] acc_reg\[0\] VGND VGND VPWR VPWR _1236_ sky130_fd_sc_hd__and3_1
X_2313_ _0619_ _0628_ _0633_ _0604_ my_mul.x2\[6\] VGND VGND VPWR VPWR _0635_ sky130_fd_sc_hd__a32o_1
X_2175_ my_sum_sub.al_mb\[7\] my_sum_sub.al_ma\[7\] VGND VGND VPWR VPWR _0510_ sky130_fd_sc_hd__and2b_1
X_2244_ my_sum_sub.al_b_larger _0529_ VGND VGND VPWR VPWR _0576_ sky130_fd_sc_hd__nand2_1
XTAP_TAPCELL_ROW_48_450 VGND VPWR sky130_fd_sc_hd__tapvpwrvgnd_1
XFILLER_33_193 VGND VGND VPWR VPWR sky130_fd_sc_hd__decap_3
X_1959_ _1084_ _0361_ _0367_ VGND VGND VPWR VPWR _0368_ sky130_fd_sc_hd__and3b_2
XFILLER_21_366 VGND VGND VPWR VPWR sky130_fd_sc_hd__decap_3
XFILLER_48_208 VGND VGND VPWR VPWR sky130_fd_sc_hd__decap_3
XFILLER_0_259 VGND VGND VPWR VPWR sky130_fd_sc_hd__fill_1
XFILLER_0_237 VGND VGND VPWR VPWR sky130_fd_sc_hd__decap_3
XTAP_TAPCELL_ROW_54_486 VGND VPWR sky130_fd_sc_hd__tapvpwrvgnd_1
XFILLER_62_299 VGND VGND VPWR VPWR sky130_fd_sc_hd__decap_3
XFILLER_62_277 VGND VGND VPWR VPWR sky130_fd_sc_hd__decap_3
XFILLER_62_222 VGND VGND VPWR VPWR sky130_fd_sc_hd__fill_2
XFILLER_62_200 VGND VGND VPWR VPWR sky130_fd_sc_hd__decap_3
XFILLER_46_90 VGND VGND VPWR VPWR sky130_fd_sc_hd__fill_1
Xclkbuf_0_clk clk VGND VGND VPWR VPWR clknet_0_clk sky130_fd_sc_hd__clkbuf_16
X_2931_ net2 VGND VGND VPWR VPWR _0027_ sky130_fd_sc_hd__inv_2
X_1813_ _1355_ _1356_ _1354_ VGND VGND VPWR VPWR _1357_ sky130_fd_sc_hd__a21o_1
X_1744_ _1276_ _1279_ VGND VGND VPWR VPWR _1288_ sky130_fd_sc_hd__xnor2_1
X_2862_ net2 VGND VGND VPWR VPWR _0143_ sky130_fd_sc_hd__inv_2
Xhold304 acc_reg\[2\] VGND VGND VPWR VPWR net309 sky130_fd_sc_hd__dlygate4sd3_1
X_2793_ net235 net190 _1044_ net239 VGND VGND VPWR VPWR _1045_ sky130_fd_sc_hd__a211o_1
X_1675_ my_mul.x2\[2\] _1218_ VGND VGND VPWR VPWR _1219_ sky130_fd_sc_hd__xnor2_1
XPHY_EDGE_ROW_15_Right_15 VGND VGND VPWR VPWR sky130_fd_sc_hd__decap_3
X_2227_ net134 net207 _0546_ VGND VGND VPWR VPWR _0562_ sky130_fd_sc_hd__a21o_1
XFILLER_53_244 VGND VGND VPWR VPWR sky130_fd_sc_hd__decap_3
XFILLER_53_211 VGND VGND VPWR VPWR sky130_fd_sc_hd__decap_3
X_2158_ net310 _0481_ _0504_ VGND VGND VPWR VPWR _0341_ sky130_fd_sc_hd__mux2_1
X_2089_ _0484_ _0485_ net280 VGND VGND VPWR VPWR _0486_ sky130_fd_sc_hd__o21a_1
XFILLER_26_38 VGND VGND VPWR VPWR sky130_fd_sc_hd__decap_3
XPHY_EDGE_ROW_24_Right_24 VGND VGND VPWR VPWR sky130_fd_sc_hd__decap_3
XTAP_TAPCELL_ROW_51_467 VGND VPWR sky130_fd_sc_hd__tapvpwrvgnd_1
XFILLER_42_26 VGND VGND VPWR VPWR sky130_fd_sc_hd__fill_2
XPHY_EDGE_ROW_33_Right_33 VGND VGND VPWR VPWR sky130_fd_sc_hd__decap_3
XFILLER_5_329 VGND VGND VPWR VPWR sky130_fd_sc_hd__decap_3
XTAP_TAPCELL_ROW_8_189 VGND VPWR sky130_fd_sc_hd__tapvpwrvgnd_1
XFILLER_44_288 VGND VGND VPWR VPWR sky130_fd_sc_hd__decap_3
XFILLER_44_266 VGND VGND VPWR VPWR sky130_fd_sc_hd__fill_1
XFILLER_44_200 VGND VGND VPWR VPWR sky130_fd_sc_hd__decap_3
XPHY_EDGE_ROW_42_Right_42 VGND VGND VPWR VPWR sky130_fd_sc_hd__decap_3
XPHY_EDGE_ROW_32_Left_95 VGND VGND VPWR VPWR sky130_fd_sc_hd__decap_3
XFILLER_29_296 VGND VGND VPWR VPWR sky130_fd_sc_hd__decap_3
XPHY_EDGE_ROW_51_Right_51 VGND VGND VPWR VPWR sky130_fd_sc_hd__decap_3
X_3130_ clknet_4_7_0_clk net55 _0041_ VGND VGND VPWR VPWR shift_out\[3\] sky130_fd_sc_hd__dfrtp_1
XPHY_EDGE_ROW_60_Right_60 VGND VGND VPWR VPWR sky130_fd_sc_hd__decap_3
X_3061_ clknet_4_15_0_clk net277 _0157_ VGND VGND VPWR VPWR my_sum_sub.cm_mant\[1\]
+ sky130_fd_sc_hd__dfrtp_1
XFILLER_35_255 VGND VGND VPWR VPWR sky130_fd_sc_hd__fill_1
X_2012_ net64 _1099_ _0418_ _0419_ VGND VGND VPWR VPWR _0236_ sky130_fd_sc_hd__o22a_1
XFILLER_50_236 VGND VGND VPWR VPWR sky130_fd_sc_hd__decap_3
X_2914_ net2 VGND VGND VPWR VPWR _0195_ sky130_fd_sc_hd__inv_2
X_2845_ net2 VGND VGND VPWR VPWR _0126_ sky130_fd_sc_hd__inv_2
X_1727_ my_mul.x2\[5\] _1237_ _1238_ _1235_ VGND VGND VPWR VPWR _1271_ sky130_fd_sc_hd__o211a_1
X_1658_ _1187_ _1195_ _1200_ VGND VGND VPWR VPWR _1202_ sky130_fd_sc_hd__and3_1
Xhold167 _0357_ VGND VGND VPWR VPWR net172 sky130_fd_sc_hd__dlygate4sd3_1
Xhold101 my_sum_sub.al_exp\[0\] VGND VGND VPWR VPWR net106 sky130_fd_sc_hd__dlygate4sd3_1
Xhold112 my_sum_sub.al_exp\[5\] VGND VGND VPWR VPWR net117 sky130_fd_sc_hd__dlygate4sd3_1
Xhold123 _0332_ VGND VGND VPWR VPWR net128 sky130_fd_sc_hd__dlygate4sd3_1
Xhold156 my_sum_sub.result\[12\] VGND VGND VPWR VPWR net161 sky130_fd_sc_hd__dlygate4sd3_1
X_2776_ _0972_ _1036_ net225 VGND VGND VPWR VPWR _0256_ sky130_fd_sc_hd__mux2_1
Xhold134 _0261_ VGND VGND VPWR VPWR net139 sky130_fd_sc_hd__dlygate4sd3_1
XFILLER_12_29 VGND VGND VPWR VPWR sky130_fd_sc_hd__fill_1
Xhold145 my_sum_sub.result\[11\] VGND VGND VPWR VPWR net150 sky130_fd_sc_hd__dlygate4sd3_1
XFILLER_58_336 VGND VGND VPWR VPWR sky130_fd_sc_hd__decap_3
X_1589_ my_mul.x2\[8\] acc_reg\[8\] _1131_ VGND VGND VPWR VPWR _1133_ sky130_fd_sc_hd__a21oi_1
Xhold189 my_divider.remainder_reg\[3\] VGND VGND VPWR VPWR net194 sky130_fd_sc_hd__dlygate4sd3_1
Xhold178 _0001_ VGND VGND VPWR VPWR net183 sky130_fd_sc_hd__dlygate4sd3_1
XFILLER_53_25 VGND VGND VPWR VPWR sky130_fd_sc_hd__fill_1
XFILLER_41_247 VGND VGND VPWR VPWR sky130_fd_sc_hd__fill_1
XFILLER_26_200 VGND VGND VPWR VPWR sky130_fd_sc_hd__decap_3
XFILLER_1_365 VGND VGND VPWR VPWR sky130_fd_sc_hd__decap_3
XFILLER_32_214 VGND VGND VPWR VPWR sky130_fd_sc_hd__decap_3
X_1512_ net231 net190 _1062_ VGND VGND VPWR VPWR _0244_ sky130_fd_sc_hd__mux2_1
X_2561_ _0815_ _0820_ _0839_ _0857_ VGND VGND VPWR VPWR _0860_ sky130_fd_sc_hd__or4_1
X_2492_ _0776_ _0785_ _0759_ _0767_ _0769_ VGND VGND VPWR VPWR _0791_ sky130_fd_sc_hd__o2111a_1
X_2630_ _0928_ VGND VGND VPWR VPWR _0929_ sky130_fd_sc_hd__inv_2
X_3113_ clknet_4_7_0_clk _0209_ _0024_ VGND VGND VPWR VPWR shift_in\[2\] sky130_fd_sc_hd__dfrtp_1
XFILLER_4_96 VGND VGND VPWR VPWR sky130_fd_sc_hd__fill_1
XFILLER_4_74 VGND VGND VPWR VPWR sky130_fd_sc_hd__fill_2
X_3044_ clknet_4_15_0_clk _0303_ _0140_ VGND VGND VPWR VPWR my_sum_sub.al_ma\[3\]
+ sky130_fd_sc_hd__dfrtp_1
XFILLER_23_214 VGND VGND VPWR VPWR sky130_fd_sc_hd__decap_3
XTAP_TAPCELL_ROW_18_250 VGND VPWR sky130_fd_sc_hd__tapvpwrvgnd_1
X_2828_ net5 VGND VGND VPWR VPWR _0109_ sky130_fd_sc_hd__inv_2
X_2759_ _0992_ _1026_ _1002_ VGND VGND VPWR VPWR _1028_ sky130_fd_sc_hd__o21ai_1
XFILLER_58_177 VGND VGND VPWR VPWR sky130_fd_sc_hd__decap_3
XFILLER_58_144 VGND VGND VPWR VPWR sky130_fd_sc_hd__decap_3
XFILLER_58_111 VGND VGND VPWR VPWR sky130_fd_sc_hd__decap_3
XFILLER_58_100 VGND VGND VPWR VPWR sky130_fd_sc_hd__decap_3
XFILLER_46_317 VGND VGND VPWR VPWR sky130_fd_sc_hd__fill_2
XTAP_TAPCELL_ROW_1_140 VGND VPWR sky130_fd_sc_hd__tapvpwrvgnd_1
XFILLER_14_269 VGND VGND VPWR VPWR sky130_fd_sc_hd__decap_3
XFILLER_49_122 VGND VGND VPWR VPWR sky130_fd_sc_hd__decap_3
XFILLER_49_100 VGND VGND VPWR VPWR sky130_fd_sc_hd__decap_3
XFILLER_36_9 VGND VGND VPWR VPWR sky130_fd_sc_hd__decap_3
XFILLER_1_151 VGND VGND VPWR VPWR sky130_fd_sc_hd__fill_1
XFILLER_49_177 VGND VGND VPWR VPWR sky130_fd_sc_hd__fill_1
XFILLER_60_342 VGND VGND VPWR VPWR sky130_fd_sc_hd__decap_3
X_1992_ _1110_ _0391_ _0400_ VGND VGND VPWR VPWR _0401_ sky130_fd_sc_hd__nand3b_1
Xclkload10 clknet_4_11_0_clk VGND VGND VPWR VPWR clkload10/Y sky130_fd_sc_hd__clkinv_8
XFILLER_20_228 VGND VGND VPWR VPWR sky130_fd_sc_hd__fill_2
XFILLER_9_284 VGND VGND VPWR VPWR sky130_fd_sc_hd__decap_3
XFILLER_9_295 VGND VGND VPWR VPWR sky130_fd_sc_hd__decap_3
XTAP_TAPCELL_ROW_15_231 VGND VPWR sky130_fd_sc_hd__tapvpwrvgnd_1
X_2544_ _0829_ _0840_ VGND VGND VPWR VPWR _0843_ sky130_fd_sc_hd__xnor2_1
X_2475_ _0748_ _0751_ _0772_ _0773_ VGND VGND VPWR VPWR _0774_ sky130_fd_sc_hd__o2bb2a_1
X_2613_ my_sum_sub.cm_exp\[5\] _0908_ _0911_ _0907_ VGND VGND VPWR VPWR _0912_ sky130_fd_sc_hd__o22a_1
XFILLER_43_309 VGND VGND VPWR VPWR sky130_fd_sc_hd__fill_1
XFILLER_34_27 VGND VGND VPWR VPWR sky130_fd_sc_hd__fill_1
X_3027_ clknet_4_10_0_clk _0286_ _0123_ VGND VGND VPWR VPWR my_sum_sub.result\[10\]
+ sky130_fd_sc_hd__dfrtp_1
Xclkload4 clknet_4_5_0_clk VGND VGND VPWR VPWR clkload4/Y sky130_fd_sc_hd__inv_12
XFILLER_59_57 VGND VGND VPWR VPWR sky130_fd_sc_hd__decap_3
XFILLER_59_24 VGND VGND VPWR VPWR sky130_fd_sc_hd__decap_3
XFILLER_1_6 VGND VGND VPWR VPWR sky130_fd_sc_hd__fill_1
XFILLER_46_125 VGND VGND VPWR VPWR sky130_fd_sc_hd__decap_3
XTAP_TAPCELL_ROW_29_323 VGND VPWR sky130_fd_sc_hd__tapvpwrvgnd_1
XFILLER_19_328 VGND VGND VPWR VPWR sky130_fd_sc_hd__fill_1
XFILLER_54_191 VGND VGND VPWR VPWR sky130_fd_sc_hd__decap_3
XFILLER_10_250 VGND VGND VPWR VPWR sky130_fd_sc_hd__fill_2
XTAP_TAPCELL_ROW_12_212 VGND VPWR sky130_fd_sc_hd__tapvpwrvgnd_1
X_2191_ _0522_ _0525_ VGND VGND VPWR VPWR _0526_ sky130_fd_sc_hd__nand2_1
X_2260_ my_sum_sub.al_b_larger _0538_ _0546_ VGND VGND VPWR VPWR _0589_ sky130_fd_sc_hd__o21ai_1
XFILLER_37_136 VGND VGND VPWR VPWR sky130_fd_sc_hd__decap_3
XFILLER_60_183 VGND VGND VPWR VPWR sky130_fd_sc_hd__fill_1
XFILLER_52_128 VGND VGND VPWR VPWR sky130_fd_sc_hd__decap_3
XFILLER_52_117 VGND VGND VPWR VPWR sky130_fd_sc_hd__fill_1
XFILLER_37_169 VGND VGND VPWR VPWR sky130_fd_sc_hd__fill_2
X_1975_ _1052_ acc_reg\[7\] VGND VGND VPWR VPWR _0384_ sky130_fd_sc_hd__and2_2
XFILLER_20_29 VGND VGND VPWR VPWR sky130_fd_sc_hd__decap_3
X_2527_ my_sum_sub.cm_mant\[4\] _0824_ _0825_ VGND VGND VPWR VPWR _0826_ sky130_fd_sc_hd__a21o_1
Xhold38 _0231_ VGND VGND VPWR VPWR net43 sky130_fd_sc_hd__dlygate4sd3_1
Xhold27 _0222_ VGND VGND VPWR VPWR net32 sky130_fd_sc_hd__dlygate4sd3_1
X_2458_ _0740_ _0746_ _0754_ _0756_ VGND VGND VPWR VPWR _0757_ sky130_fd_sc_hd__a31o_1
Xhold49 shift_out\[3\] VGND VGND VPWR VPWR net54 sky130_fd_sc_hd__dlygate4sd3_1
X_2389_ net105 _0607_ net261 VGND VGND VPWR VPWR _0296_ sky130_fd_sc_hd__a21o_1
XTAP_TAPCELL_ROW_26_304 VGND VPWR sky130_fd_sc_hd__tapvpwrvgnd_1
XFILLER_16_309 VGND VGND VPWR VPWR sky130_fd_sc_hd__decap_3
XFILLER_51_172 VGND VGND VPWR VPWR sky130_fd_sc_hd__decap_3
XFILLER_24_353 VGND VGND VPWR VPWR sky130_fd_sc_hd__fill_2
XFILLER_59_272 VGND VGND VPWR VPWR sky130_fd_sc_hd__decap_3
XFILLER_42_150 VGND VGND VPWR VPWR sky130_fd_sc_hd__fill_1
XFILLER_34_139 VGND VGND VPWR VPWR sky130_fd_sc_hd__fill_1
XFILLER_19_169 VGND VGND VPWR VPWR sky130_fd_sc_hd__decap_3
X_1691_ my_mul.x2\[6\] acc_reg\[1\] acc_reg\[0\] VGND VGND VPWR VPWR _1235_ sky130_fd_sc_hd__a21o_1
X_1760_ my_mul.x2\[0\] _1302_ VGND VGND VPWR VPWR _1304_ sky130_fd_sc_hd__and2_1
XFILLER_42_194 VGND VGND VPWR VPWR sky130_fd_sc_hd__fill_2
XTAP_TAPCELL_ROW_40_395 VGND VPWR sky130_fd_sc_hd__tapvpwrvgnd_1
X_2312_ _0628_ _0633_ VGND VGND VPWR VPWR _0634_ sky130_fd_sc_hd__nand2_1
X_2174_ my_sum_sub.al_ma\[7\] my_sum_sub.al_mb\[7\] VGND VGND VPWR VPWR _0509_ sky130_fd_sc_hd__and2b_1
X_2243_ net243 _0575_ net127 VGND VGND VPWR VPWR _0325_ sky130_fd_sc_hd__mux2_1
XFILLER_25_117 VGND VGND VPWR VPWR sky130_fd_sc_hd__fill_2
X_1958_ _0364_ _0365_ _0366_ VGND VGND VPWR VPWR _0367_ sky130_fd_sc_hd__or3_1
X_1889_ _1138_ _1141_ VGND VGND VPWR VPWR _1433_ sky130_fd_sc_hd__nor2_1
XFILLER_0_249 VGND VGND VPWR VPWR sky130_fd_sc_hd__decap_3
XFILLER_56_58 VGND VGND VPWR VPWR sky130_fd_sc_hd__decap_3
XTAP_TAPCELL_ROW_54_487 VGND VPWR sky130_fd_sc_hd__tapvpwrvgnd_1
XFILLER_24_161 VGND VGND VPWR VPWR sky130_fd_sc_hd__decap_3
XFILLER_16_139 VGND VGND VPWR VPWR sky130_fd_sc_hd__fill_1
XFILLER_24_183 VGND VGND VPWR VPWR sky130_fd_sc_hd__fill_1
XFILLER_62_256 VGND VGND VPWR VPWR sky130_fd_sc_hd__decap_3
XFILLER_62_234 VGND VGND VPWR VPWR sky130_fd_sc_hd__decap_3
X_2861_ net2 VGND VGND VPWR VPWR _0142_ sky130_fd_sc_hd__inv_2
X_2930_ net2 VGND VGND VPWR VPWR _0026_ sky130_fd_sc_hd__inv_2
XFILLER_15_161 VGND VGND VPWR VPWR sky130_fd_sc_hd__decap_3
XFILLER_15_172 VGND VGND VPWR VPWR sky130_fd_sc_hd__fill_2
X_1812_ _1341_ _1353_ VGND VGND VPWR VPWR _1356_ sky130_fd_sc_hd__xor2_1
X_1674_ _1216_ _1217_ VGND VGND VPWR VPWR _1218_ sky130_fd_sc_hd__nor2_1
X_1743_ _1277_ _1282_ VGND VGND VPWR VPWR _1287_ sky130_fd_sc_hd__xor2_1
Xhold305 acc_reg\[3\] VGND VGND VPWR VPWR net310 sky130_fd_sc_hd__dlygate4sd3_1
XFILLER_30_197 VGND VGND VPWR VPWR sky130_fd_sc_hd__decap_3
XFILLER_30_175 VGND VGND VPWR VPWR sky130_fd_sc_hd__decap_3
X_2792_ net235 net190 net92 VGND VGND VPWR VPWR _1044_ sky130_fd_sc_hd__o21a_1
X_2226_ _0544_ _0560_ _0548_ VGND VGND VPWR VPWR _0561_ sky130_fd_sc_hd__o21ai_1
X_2157_ net312 _0476_ _0504_ VGND VGND VPWR VPWR _0342_ sky130_fd_sc_hd__mux2_1
X_2088_ net115 _1088_ _1090_ net33 VGND VGND VPWR VPWR _0485_ sky130_fd_sc_hd__a22o_1
XTAP_TAPCELL_ROW_51_468 VGND VPWR sky130_fd_sc_hd__tapvpwrvgnd_1
XFILLER_44_212 VGND VGND VPWR VPWR sky130_fd_sc_hd__decap_3
XFILLER_16_83 VGND VGND VPWR VPWR sky130_fd_sc_hd__fill_1
XFILLER_4_352 VGND VGND VPWR VPWR sky130_fd_sc_hd__decap_3
XFILLER_12_197 VGND VGND VPWR VPWR sky130_fd_sc_hd__fill_1
X_3060_ clknet_4_14_0_clk net199 _0156_ VGND VGND VPWR VPWR my_sum_sub.cm_mant\[0\]
+ sky130_fd_sc_hd__dfrtp_1
XFILLER_35_278 VGND VGND VPWR VPWR sky130_fd_sc_hd__fill_2
XFILLER_35_234 VGND VGND VPWR VPWR sky130_fd_sc_hd__fill_2
XFILLER_35_223 VGND VGND VPWR VPWR sky130_fd_sc_hd__fill_1
X_2011_ net38 _1064_ _1097_ acc_reg\[13\] _1100_ VGND VGND VPWR VPWR _0419_ sky130_fd_sc_hd__a221o_1
XFILLER_50_248 VGND VGND VPWR VPWR sky130_fd_sc_hd__decap_3
X_2913_ net2 VGND VGND VPWR VPWR _0194_ sky130_fd_sc_hd__inv_2
X_2844_ net2 VGND VGND VPWR VPWR _0125_ sky130_fd_sc_hd__inv_2
X_1726_ _1268_ _1269_ VGND VGND VPWR VPWR _1270_ sky130_fd_sc_hd__nor2_1
X_1657_ _1195_ _1200_ _1187_ VGND VGND VPWR VPWR _1201_ sky130_fd_sc_hd__a21oi_1
Xhold124 my_sum_sub.al_mb\[4\] VGND VGND VPWR VPWR net129 sky130_fd_sc_hd__dlygate4sd3_1
Xhold135 my_sum_sub.al_mb\[2\] VGND VGND VPWR VPWR net140 sky130_fd_sc_hd__dlygate4sd3_1
X_1588_ my_mul.x2\[8\] acc_reg\[8\] _1131_ VGND VGND VPWR VPWR _1132_ sky130_fd_sc_hd__and3_1
Xhold102 _0329_ VGND VGND VPWR VPWR net107 sky130_fd_sc_hd__dlygate4sd3_1
Xhold113 _0334_ VGND VGND VPWR VPWR net118 sky130_fd_sc_hd__dlygate4sd3_1
Xhold157 _0288_ VGND VGND VPWR VPWR net162 sky130_fd_sc_hd__dlygate4sd3_1
X_2775_ net219 net168 _1034_ _1038_ VGND VGND VPWR VPWR _0257_ sky130_fd_sc_hd__o211a_1
Xhold179 state\[0\] VGND VGND VPWR VPWR net184 sky130_fd_sc_hd__dlygate4sd3_1
Xhold168 state\[5\] VGND VGND VPWR VPWR net173 sky130_fd_sc_hd__dlygate4sd3_1
Xhold146 _0287_ VGND VGND VPWR VPWR net151 sky130_fd_sc_hd__dlygate4sd3_1
XFILLER_58_348 VGND VGND VPWR VPWR sky130_fd_sc_hd__decap_3
XFILLER_58_315 VGND VGND VPWR VPWR sky130_fd_sc_hd__decap_3
XFILLER_58_304 VGND VGND VPWR VPWR sky130_fd_sc_hd__decap_3
X_2209_ _0511_ _0512_ VGND VGND VPWR VPWR _0544_ sky130_fd_sc_hd__nor2_1
XFILLER_37_49 VGND VGND VPWR VPWR sky130_fd_sc_hd__decap_3
XFILLER_49_337 VGND VGND VPWR VPWR sky130_fd_sc_hd__decap_3
XFILLER_49_304 VGND VGND VPWR VPWR sky130_fd_sc_hd__decap_3
XTAP_TAPCELL_ROW_4_160 VGND VPWR sky130_fd_sc_hd__tapvpwrvgnd_1
XFILLER_17_278 VGND VGND VPWR VPWR sky130_fd_sc_hd__fill_2
XFILLER_43_92 VGND VGND VPWR VPWR sky130_fd_sc_hd__decap_3
XFILLER_32_259 VGND VGND VPWR VPWR sky130_fd_sc_hd__fill_1
XFILLER_4_193 VGND VGND VPWR VPWR sky130_fd_sc_hd__decap_3
X_2560_ _0856_ _0858_ VGND VGND VPWR VPWR _0859_ sky130_fd_sc_hd__nand2_1
X_2491_ _0763_ _0789_ VGND VGND VPWR VPWR _0790_ sky130_fd_sc_hd__nor2_1
X_1511_ net223 net235 _1062_ VGND VGND VPWR VPWR _0245_ sky130_fd_sc_hd__mux2_1
X_3043_ clknet_4_15_0_clk _0302_ _0139_ VGND VGND VPWR VPWR my_sum_sub.al_ma\[2\]
+ sky130_fd_sc_hd__dfrtp_1
X_3112_ clknet_4_5_0_clk _0208_ _0023_ VGND VGND VPWR VPWR shift_in\[1\] sky130_fd_sc_hd__dfrtp_1
XTAP_TAPCELL_ROW_61_530 VGND VPWR sky130_fd_sc_hd__tapvpwrvgnd_1
XTAP_TAPCELL_ROW_18_251 VGND VPWR sky130_fd_sc_hd__tapvpwrvgnd_1
XFILLER_31_281 VGND VGND VPWR VPWR sky130_fd_sc_hd__fill_1
X_2758_ net138 _1002_ VGND VGND VPWR VPWR _1027_ sky130_fd_sc_hd__or2_1
X_2827_ net2 VGND VGND VPWR VPWR _0108_ sky130_fd_sc_hd__inv_2
XFILLER_58_123 VGND VGND VPWR VPWR sky130_fd_sc_hd__decap_3
X_1709_ _1250_ _1252_ VGND VGND VPWR VPWR _1253_ sky130_fd_sc_hd__and2b_1
XFILLER_48_15 VGND VGND VPWR VPWR sky130_fd_sc_hd__decap_3
X_2689_ net168 _1093_ VGND VGND VPWR VPWR _0972_ sky130_fd_sc_hd__and2_4
XFILLER_58_189 VGND VGND VPWR VPWR sky130_fd_sc_hd__decap_3
XFILLER_58_156 VGND VGND VPWR VPWR sky130_fd_sc_hd__decap_3
XFILLER_46_329 VGND VGND VPWR VPWR sky130_fd_sc_hd__decap_3
XTAP_TAPCELL_ROW_1_141 VGND VPWR sky130_fd_sc_hd__tapvpwrvgnd_1
XFILLER_14_248 VGND VGND VPWR VPWR sky130_fd_sc_hd__fill_1
XFILLER_49_134 VGND VGND VPWR VPWR sky130_fd_sc_hd__decap_3
XFILLER_1_163 VGND VGND VPWR VPWR sky130_fd_sc_hd__decap_3
XFILLER_60_365 VGND VGND VPWR VPWR sky130_fd_sc_hd__decap_3
XFILLER_60_354 VGND VGND VPWR VPWR sky130_fd_sc_hd__decap_3
XFILLER_60_321 VGND VGND VPWR VPWR sky130_fd_sc_hd__decap_3
XFILLER_54_91 VGND VGND VPWR VPWR sky130_fd_sc_hd__decap_3
XTAP_TAPCELL_ROW_15_232 VGND VPWR sky130_fd_sc_hd__tapvpwrvgnd_1
XFILLER_62_3 VGND VGND VPWR VPWR sky130_fd_sc_hd__decap_3
Xclkload11 clknet_4_12_0_clk VGND VGND VPWR VPWR clkload11/Y sky130_fd_sc_hd__inv_16
X_1991_ _1112_ _1137_ _0399_ VGND VGND VPWR VPWR _0400_ sky130_fd_sc_hd__or3b_1
XFILLER_13_292 VGND VGND VPWR VPWR sky130_fd_sc_hd__fill_1
X_2612_ _0879_ _0880_ _0905_ _0910_ VGND VGND VPWR VPWR _0911_ sky130_fd_sc_hd__a31o_1
X_2543_ _0812_ _0841_ VGND VGND VPWR VPWR _0842_ sky130_fd_sc_hd__xor2_2
X_2474_ _0704_ _0718_ _0749_ _0715_ VGND VGND VPWR VPWR _0773_ sky130_fd_sc_hd__o22a_1
XFILLER_55_148 VGND VGND VPWR VPWR sky130_fd_sc_hd__decap_3
XTAP_TAPCELL_ROW_38_379 VGND VPWR sky130_fd_sc_hd__tapvpwrvgnd_1
XFILLER_28_307 VGND VGND VPWR VPWR sky130_fd_sc_hd__fill_1
X_3026_ clknet_4_11_0_clk _0285_ _0122_ VGND VGND VPWR VPWR my_sum_sub.result\[9\]
+ sky130_fd_sc_hd__dfrtp_1
XFILLER_18_29 VGND VGND VPWR VPWR sky130_fd_sc_hd__fill_2
Xclkload5 clknet_4_6_0_clk VGND VGND VPWR VPWR clkload5/Y sky130_fd_sc_hd__clkinv_8
XFILLER_50_49 VGND VGND VPWR VPWR sky130_fd_sc_hd__decap_3
XFILLER_50_38 VGND VGND VPWR VPWR sky130_fd_sc_hd__decap_3
XFILLER_59_69 VGND VGND VPWR VPWR sky130_fd_sc_hd__fill_1
XFILLER_59_47 VGND VGND VPWR VPWR sky130_fd_sc_hd__fill_2
XFILLER_54_181 VGND VGND VPWR VPWR sky130_fd_sc_hd__decap_3
XFILLER_42_332 VGND VGND VPWR VPWR sky130_fd_sc_hd__fill_1
XTAP_TAPCELL_ROW_29_324 VGND VPWR sky130_fd_sc_hd__tapvpwrvgnd_1
XFILLER_27_340 VGND VGND VPWR VPWR sky130_fd_sc_hd__decap_3
XFILLER_10_273 VGND VGND VPWR VPWR sky130_fd_sc_hd__decap_3
XTAP_TAPCELL_ROW_12_213 VGND VPWR sky130_fd_sc_hd__tapvpwrvgnd_1
X_2190_ _1056_ my_sum_sub.al_ma\[0\] _0524_ VGND VGND VPWR VPWR _0525_ sky130_fd_sc_hd__a21o_1
XFILLER_37_148 VGND VGND VPWR VPWR sky130_fd_sc_hd__decap_3
XFILLER_18_351 VGND VGND VPWR VPWR sky130_fd_sc_hd__fill_1
XFILLER_60_195 VGND VGND VPWR VPWR sky130_fd_sc_hd__fill_1
X_1974_ _1050_ acc_reg\[14\] VGND VGND VPWR VPWR _0383_ sky130_fd_sc_hd__or2_2
Xhold39 shift_out\[4\] VGND VGND VPWR VPWR net44 sky130_fd_sc_hd__dlygate4sd3_1
X_2526_ net8 my_sum_sub.cm_mant\[5\] my_sum_sub.cm_mant\[3\] _0729_ VGND VGND VPWR
+ VPWR _0825_ sky130_fd_sc_hd__a22o_1
X_2388_ net260 _1055_ _0606_ acc_reg\[11\] VGND VGND VPWR VPWR _0692_ sky130_fd_sc_hd__a22o_1
Xhold28 my_sum_sub.result\[2\] VGND VGND VPWR VPWR net33 sky130_fd_sc_hd__dlygate4sd3_1
X_2457_ _0750_ _0755_ VGND VGND VPWR VPWR _0756_ sky130_fd_sc_hd__or2_1
XFILLER_45_38 VGND VGND VPWR VPWR sky130_fd_sc_hd__fill_1
XFILLER_43_107 VGND VGND VPWR VPWR sky130_fd_sc_hd__decap_3
XFILLER_36_192 VGND VGND VPWR VPWR sky130_fd_sc_hd__decap_3
XTAP_TAPCELL_ROW_26_305 VGND VPWR sky130_fd_sc_hd__tapvpwrvgnd_1
X_3009_ clknet_4_2_0_clk net246 _0105_ VGND VGND VPWR VPWR my_divider.remainder_reg\[8\]
+ sky130_fd_sc_hd__dfrtp_2
XFILLER_61_15 VGND VGND VPWR VPWR sky130_fd_sc_hd__decap_3
XFILLER_51_184 VGND VGND VPWR VPWR sky130_fd_sc_hd__decap_3
XFILLER_51_151 VGND VGND VPWR VPWR sky130_fd_sc_hd__decap_3
XFILLER_24_365 VGND VGND VPWR VPWR sky130_fd_sc_hd__decap_3
XFILLER_10_85 VGND VGND VPWR VPWR sky130_fd_sc_hd__fill_1
XFILLER_59_284 VGND VGND VPWR VPWR sky130_fd_sc_hd__decap_3
XFILLER_59_251 VGND VGND VPWR VPWR sky130_fd_sc_hd__decap_3
XFILLER_27_181 VGND VGND VPWR VPWR sky130_fd_sc_hd__fill_1
XFILLER_15_321 VGND VGND VPWR VPWR sky130_fd_sc_hd__decap_3
X_1690_ my_mul.x2\[5\] acc_reg\[3\] _1211_ _1212_ VGND VGND VPWR VPWR _1234_ sky130_fd_sc_hd__o2bb2a_1
XTAP_TAPCELL_ROW_40_396 VGND VPWR sky130_fd_sc_hd__tapvpwrvgnd_1
XFILLER_30_368 VGND VGND VPWR VPWR sky130_fd_sc_hd__fill_2
X_2242_ _0544_ _0574_ VGND VGND VPWR VPWR _0575_ sky130_fd_sc_hd__xor2_1
X_2311_ _0624_ _0632_ _1153_ VGND VGND VPWR VPWR _0633_ sky130_fd_sc_hd__mux2_1
XFILLER_25_3 VGND VGND VPWR VPWR sky130_fd_sc_hd__fill_2
X_2173_ net148 net175 net127 VGND VGND VPWR VPWR _0328_ sky130_fd_sc_hd__mux2_1
XFILLER_15_19 VGND VGND VPWR VPWR sky130_fd_sc_hd__decap_3
XFILLER_33_151 VGND VGND VPWR VPWR sky130_fd_sc_hd__decap_3
X_1957_ acc_reg\[15\] acc_reg\[6\] acc_reg\[5\] acc_reg\[4\] VGND VGND VPWR VPWR _0366_
+ sky130_fd_sc_hd__or4_1
X_1888_ _1152_ _1429_ VGND VGND VPWR VPWR _1432_ sky130_fd_sc_hd__xnor2_1
XFILLER_0_228 VGND VGND VPWR VPWR sky130_fd_sc_hd__decap_3
X_2509_ _0802_ _0804_ _0759_ _0799_ _0801_ VGND VGND VPWR VPWR _0808_ sky130_fd_sc_hd__o2111a_1
XFILLER_56_243 VGND VGND VPWR VPWR sky130_fd_sc_hd__decap_3
XFILLER_56_37 VGND VGND VPWR VPWR sky130_fd_sc_hd__decap_3
XFILLER_56_15 VGND VGND VPWR VPWR sky130_fd_sc_hd__fill_1
XTAP_TAPCELL_ROW_54_488 VGND VPWR sky130_fd_sc_hd__tapvpwrvgnd_1
XFILLER_24_195 VGND VGND VPWR VPWR sky130_fd_sc_hd__fill_1
XFILLER_12_302 VGND VGND VPWR VPWR sky130_fd_sc_hd__fill_1
XFILLER_12_368 VGND VGND VPWR VPWR sky130_fd_sc_hd__fill_2
XFILLER_21_84 VGND VGND VPWR VPWR sky130_fd_sc_hd__decap_3
XFILLER_62_246 VGND VGND VPWR VPWR sky130_fd_sc_hd__decap_3
XFILLER_47_287 VGND VGND VPWR VPWR sky130_fd_sc_hd__decap_3
XFILLER_47_276 VGND VGND VPWR VPWR sky130_fd_sc_hd__decap_3
XFILLER_46_81 VGND VGND VPWR VPWR sky130_fd_sc_hd__decap_3
XFILLER_11_9 VGND VGND VPWR VPWR sky130_fd_sc_hd__decap_3
XFILLER_62_268 VGND VGND VPWR VPWR sky130_fd_sc_hd__decap_3
XFILLER_62_91 VGND VGND VPWR VPWR sky130_fd_sc_hd__decap_3
XFILLER_62_80 VGND VGND VPWR VPWR sky130_fd_sc_hd__decap_3
X_1811_ my_mul.x2\[0\] acc_reg\[5\] _1349_ _1348_ VGND VGND VPWR VPWR _1355_ sky130_fd_sc_hd__a31o_1
X_2860_ net2 VGND VGND VPWR VPWR _0141_ sky130_fd_sc_hd__inv_2
XFILLER_30_110 VGND VGND VPWR VPWR sky130_fd_sc_hd__decap_3
X_2791_ net291 _1040_ _1042_ VGND VGND VPWR VPWR _1043_ sky130_fd_sc_hd__a21bo_1
X_1673_ my_mul.x2\[4\] my_mul.x2\[3\] acc_reg\[6\] acc_reg\[5\] VGND VGND VPWR VPWR
+ _1217_ sky130_fd_sc_hd__and4_1
X_1742_ _1284_ _1285_ VGND VGND VPWR VPWR _1286_ sky130_fd_sc_hd__nor2_1
Xhold306 acc_reg\[5\] VGND VGND VPWR VPWR net311 sky130_fd_sc_hd__dlygate4sd3_1
X_2225_ _0543_ _0559_ _0549_ VGND VGND VPWR VPWR _0560_ sky130_fd_sc_hd__o21a_1
XFILLER_38_232 VGND VGND VPWR VPWR sky130_fd_sc_hd__decap_3
XFILLER_38_210 VGND VGND VPWR VPWR sky130_fd_sc_hd__decap_3
XFILLER_53_235 VGND VGND VPWR VPWR sky130_fd_sc_hd__fill_2
X_2087_ _0368_ _0379_ _0460_ _0483_ VGND VGND VPWR VPWR _0484_ sky130_fd_sc_hd__and4_1
X_2156_ net311 _0471_ _0504_ VGND VGND VPWR VPWR _0343_ sky130_fd_sc_hd__mux2_1
XPHY_EDGE_ROW_5_Right_5 VGND VGND VPWR VPWR sky130_fd_sc_hd__decap_3
XFILLER_61_290 VGND VGND VPWR VPWR sky130_fd_sc_hd__decap_3
XTAP_TAPCELL_ROW_51_469 VGND VPWR sky130_fd_sc_hd__tapvpwrvgnd_1
X_2989_ clknet_4_10_0_clk net230 _0085_ VGND VGND VPWR VPWR my_divider.divisor_reg\[0\]
+ sky130_fd_sc_hd__dfrtp_1
XFILLER_44_224 VGND VGND VPWR VPWR sky130_fd_sc_hd__fill_2
XFILLER_44_279 VGND VGND VPWR VPWR sky130_fd_sc_hd__decap_3
XFILLER_12_187 VGND VGND VPWR VPWR sky130_fd_sc_hd__decap_3
XFILLER_59_9 VGND VGND VPWR VPWR sky130_fd_sc_hd__decap_3
XFILLER_8_158 VGND VGND VPWR VPWR sky130_fd_sc_hd__fill_2
X_2010_ net191 _1091_ _0415_ _0417_ state\[4\] VGND VGND VPWR VPWR _0418_ sky130_fd_sc_hd__o221a_1
XTAP_TAPCELL_ROW_7_180 VGND VPWR sky130_fd_sc_hd__tapvpwrvgnd_1
XFILLER_57_91 VGND VGND VPWR VPWR sky130_fd_sc_hd__decap_3
X_2912_ net5 VGND VGND VPWR VPWR _0193_ sky130_fd_sc_hd__inv_2
XFILLER_35_213 VGND VGND VPWR VPWR sky130_fd_sc_hd__decap_3
X_1725_ _1264_ _1266_ _1267_ VGND VGND VPWR VPWR _1269_ sky130_fd_sc_hd__and3_1
XFILLER_43_290 VGND VGND VPWR VPWR sky130_fd_sc_hd__fill_1
X_2843_ net2 VGND VGND VPWR VPWR _0124_ sky130_fd_sc_hd__inv_2
X_2774_ net219 my_divider.counter\[0\] _0973_ VGND VGND VPWR VPWR _1038_ sky130_fd_sc_hd__o21ba_1
X_1656_ _1196_ _1197_ _1199_ VGND VGND VPWR VPWR _1200_ sky130_fd_sc_hd__or3_1
Xhold125 _0312_ VGND VGND VPWR VPWR net130 sky130_fd_sc_hd__dlygate4sd3_1
Xhold136 _0310_ VGND VGND VPWR VPWR net141 sky130_fd_sc_hd__dlygate4sd3_1
Xhold147 shift_in\[1\] VGND VGND VPWR VPWR net152 sky130_fd_sc_hd__dlygate4sd3_1
X_1587_ _1128_ _1129_ VGND VGND VPWR VPWR _1131_ sky130_fd_sc_hd__or2_1
Xhold169 my_sum_sub.al_sb_eff VGND VGND VPWR VPWR net174 sky130_fd_sc_hd__dlygate4sd3_1
Xhold114 my_sum_sub.al_exp\[6\] VGND VGND VPWR VPWR net119 sky130_fd_sc_hd__dlygate4sd3_1
Xhold103 my_divider.counter\[2\] VGND VGND VPWR VPWR net108 sky130_fd_sc_hd__dlygate4sd3_1
Xhold158 div_quotient\[1\] VGND VGND VPWR VPWR net163 sky130_fd_sc_hd__dlygate4sd3_1
XFILLER_58_327 VGND VGND VPWR VPWR sky130_fd_sc_hd__decap_3
X_2208_ _0513_ _0514_ VGND VGND VPWR VPWR _0543_ sky130_fd_sc_hd__nor2_1
X_2139_ net121 net158 _0500_ VGND VGND VPWR VPWR _0354_ sky130_fd_sc_hd__mux2_1
XFILLER_26_213 VGND VGND VPWR VPWR sky130_fd_sc_hd__decap_3
XFILLER_53_49 VGND VGND VPWR VPWR sky130_fd_sc_hd__fill_2
XFILLER_41_238 VGND VGND VPWR VPWR sky130_fd_sc_hd__decap_3
XFILLER_26_257 VGND VGND VPWR VPWR sky130_fd_sc_hd__decap_3
XFILLER_1_356 VGND VGND VPWR VPWR sky130_fd_sc_hd__decap_3
XFILLER_32_205 VGND VGND VPWR VPWR sky130_fd_sc_hd__decap_3
XTAP_TAPCELL_ROW_4_161 VGND VPWR sky130_fd_sc_hd__tapvpwrvgnd_1
XFILLER_57_6 VGND VGND VPWR VPWR sky130_fd_sc_hd__decap_3
X_2490_ _0765_ _0788_ VGND VGND VPWR VPWR _0789_ sky130_fd_sc_hd__nand2_1
X_1510_ net241 net239 _1062_ VGND VGND VPWR VPWR _0246_ sky130_fd_sc_hd__mux2_1
X_3042_ clknet_4_12_0_clk _0301_ _0138_ VGND VGND VPWR VPWR my_sum_sub.al_ma\[1\]
+ sky130_fd_sc_hd__dfrtp_1
X_3111_ clknet_4_7_0_clk net122 _0022_ VGND VGND VPWR VPWR shift_in\[0\] sky130_fd_sc_hd__dfrtp_1
XTAP_TAPCELL_ROW_61_531 VGND VPWR sky130_fd_sc_hd__tapvpwrvgnd_1
XTAP_TAPCELL_ROW_18_252 VGND VPWR sky130_fd_sc_hd__tapvpwrvgnd_1
X_1708_ _1249_ _1251_ VGND VGND VPWR VPWR _1252_ sky130_fd_sc_hd__nor2_1
X_2757_ _1058_ net229 _0991_ VGND VGND VPWR VPWR _1026_ sky130_fd_sc_hd__and3_1
X_2826_ net2 VGND VGND VPWR VPWR _0107_ sky130_fd_sc_hd__inv_2
X_2688_ _0958_ _0961_ _0971_ net34 _1057_ VGND VGND VPWR VPWR _0276_ sky130_fd_sc_hd__a32o_1
XFILLER_58_135 VGND VGND VPWR VPWR sky130_fd_sc_hd__decap_3
X_1639_ _1156_ _1182_ VGND VGND VPWR VPWR _1183_ sky130_fd_sc_hd__nor2_2
XFILLER_58_168 VGND VGND VPWR VPWR sky130_fd_sc_hd__decap_3
XTAP_TAPCELL_ROW_1_142 VGND VPWR sky130_fd_sc_hd__tapvpwrvgnd_1
XTAP_TAPCELL_ROW_24_288 VGND VPWR sky130_fd_sc_hd__tapvpwrvgnd_1
XFILLER_49_113 VGND VGND VPWR VPWR sky130_fd_sc_hd__decap_3
XFILLER_60_333 VGND VGND VPWR VPWR sky130_fd_sc_hd__decap_3
XFILLER_54_81 VGND VGND VPWR VPWR sky130_fd_sc_hd__decap_3
X_1990_ _0396_ _0398_ VGND VGND VPWR VPWR _0399_ sky130_fd_sc_hd__nand2b_1
XTAP_TAPCELL_ROW_15_233 VGND VPWR sky130_fd_sc_hd__tapvpwrvgnd_1
XFILLER_55_3 VGND VGND VPWR VPWR sky130_fd_sc_hd__decap_3
XPHY_EDGE_ROW_41_Left_104 VGND VGND VPWR VPWR sky130_fd_sc_hd__decap_3
Xclkload12 clknet_4_13_0_clk VGND VGND VPWR VPWR clkload12/Y sky130_fd_sc_hd__inv_12
X_2611_ _0705_ _0908_ VGND VGND VPWR VPWR _0910_ sky130_fd_sc_hd__nand2_2
X_2542_ _0830_ _0838_ _0793_ _0828_ _0822_ VGND VGND VPWR VPWR _0841_ sky130_fd_sc_hd__a2111o_1
XPHY_EDGE_ROW_50_Left_113 VGND VGND VPWR VPWR sky130_fd_sc_hd__decap_3
X_2473_ _0708_ _0720_ _0725_ _0733_ VGND VGND VPWR VPWR _0772_ sky130_fd_sc_hd__and4b_1
X_3025_ clknet_4_9_0_clk _0284_ _0121_ VGND VGND VPWR VPWR my_sum_sub.result\[8\]
+ sky130_fd_sc_hd__dfrtp_1
Xclkload6 clknet_4_7_0_clk VGND VGND VPWR VPWR clkload6/Y sky130_fd_sc_hd__inv_6
XTAP_TAPCELL_ROW_21_269 VGND VPWR sky130_fd_sc_hd__tapvpwrvgnd_1
XFILLER_11_208 VGND VGND VPWR VPWR sky130_fd_sc_hd__decap_3
XFILLER_59_15 VGND VGND VPWR VPWR sky130_fd_sc_hd__decap_3
X_2809_ net2 VGND VGND VPWR VPWR _0090_ sky130_fd_sc_hd__inv_2
XFILLER_46_138 VGND VGND VPWR VPWR sky130_fd_sc_hd__fill_2
XTAP_TAPCELL_ROW_29_325 VGND VPWR sky130_fd_sc_hd__tapvpwrvgnd_1
XFILLER_61_119 VGND VGND VPWR VPWR sky130_fd_sc_hd__fill_1
XFILLER_54_171 VGND VGND VPWR VPWR sky130_fd_sc_hd__fill_1
XFILLER_27_363 VGND VGND VPWR VPWR sky130_fd_sc_hd__decap_3
XFILLER_6_256 VGND VGND VPWR VPWR sky130_fd_sc_hd__fill_1
XFILLER_10_285 VGND VGND VPWR VPWR sky130_fd_sc_hd__decap_3
XTAP_TAPCELL_ROW_12_214 VGND VPWR sky130_fd_sc_hd__tapvpwrvgnd_1
XFILLER_41_9 VGND VGND VPWR VPWR sky130_fd_sc_hd__decap_3
XFILLER_49_92 VGND VGND VPWR VPWR sky130_fd_sc_hd__fill_1
XFILLER_45_160 VGND VGND VPWR VPWR sky130_fd_sc_hd__decap_3
XFILLER_37_127 VGND VGND VPWR VPWR sky130_fd_sc_hd__decap_3
XFILLER_60_141 VGND VGND VPWR VPWR sky130_fd_sc_hd__decap_3
X_1973_ _1150_ _0374_ _0381_ _0368_ VGND VGND VPWR VPWR _0382_ sky130_fd_sc_hd__o211a_1
X_2525_ _0823_ VGND VGND VPWR VPWR _0824_ sky130_fd_sc_hd__inv_2
X_2387_ net249 _0607_ _0691_ VGND VGND VPWR VPWR _0297_ sky130_fd_sc_hd__a21o_1
X_2456_ _0704_ _0706_ _0707_ _0734_ VGND VGND VPWR VPWR _0755_ sky130_fd_sc_hd__o22a_1
Xhold29 my_sum_sub.result\[0\] VGND VGND VPWR VPWR net34 sky130_fd_sc_hd__dlygate4sd3_1
XFILLER_36_171 VGND VGND VPWR VPWR sky130_fd_sc_hd__fill_1
XTAP_TAPCELL_ROW_26_306 VGND VPWR sky130_fd_sc_hd__tapvpwrvgnd_1
X_3008_ clknet_4_2_0_clk net287 _0104_ VGND VGND VPWR VPWR my_divider.remainder_reg\[7\]
+ sky130_fd_sc_hd__dfrtp_1
XFILLER_61_27 VGND VGND VPWR VPWR sky130_fd_sc_hd__decap_3
XFILLER_51_196 VGND VGND VPWR VPWR sky130_fd_sc_hd__decap_3
XFILLER_59_230 VGND VGND VPWR VPWR sky130_fd_sc_hd__decap_3
XFILLER_3_215 VGND VGND VPWR VPWR sky130_fd_sc_hd__decap_3
XFILLER_10_97 VGND VGND VPWR VPWR sky130_fd_sc_hd__fill_1
XFILLER_59_296 VGND VGND VPWR VPWR sky130_fd_sc_hd__decap_3
XFILLER_59_263 VGND VGND VPWR VPWR sky130_fd_sc_hd__decap_3
XFILLER_15_300 VGND VGND VPWR VPWR sky130_fd_sc_hd__decap_3
XFILLER_42_174 VGND VGND VPWR VPWR sky130_fd_sc_hd__fill_2
XFILLER_42_141 VGND VGND VPWR VPWR sky130_fd_sc_hd__decap_3
XFILLER_30_325 VGND VGND VPWR VPWR sky130_fd_sc_hd__fill_1
XFILLER_15_333 VGND VGND VPWR VPWR sky130_fd_sc_hd__decap_3
XFILLER_51_93 VGND VGND VPWR VPWR sky130_fd_sc_hd__decap_3
XTAP_TAPCELL_ROW_40_397 VGND VPWR sky130_fd_sc_hd__tapvpwrvgnd_1
X_2241_ _0560_ _0573_ _0546_ VGND VGND VPWR VPWR _0574_ sky130_fd_sc_hd__mux2_1
X_2310_ _0605_ _0630_ _0631_ _0622_ VGND VGND VPWR VPWR _0632_ sky130_fd_sc_hd__o211a_1
X_2172_ my_sum_sub.al_sa net174 my_sum_sub.al_b_larger VGND VGND VPWR VPWR _0508_
+ sky130_fd_sc_hd__mux2_1
XFILLER_2_281 VGND VGND VPWR VPWR sky130_fd_sc_hd__decap_3
X_1956_ acc_reg\[3\] acc_reg\[2\] acc_reg\[1\] acc_reg\[0\] VGND VGND VPWR VPWR _0365_
+ sky130_fd_sc_hd__or4_1
X_1887_ _1152_ _1429_ VGND VGND VPWR VPWR _1431_ sky130_fd_sc_hd__xor2_1
XFILLER_33_196 VGND VGND VPWR VPWR sky130_fd_sc_hd__decap_3
XFILLER_21_369 VGND VGND VPWR VPWR sky130_fd_sc_hd__fill_1
X_2508_ _0802_ _0804_ _0799_ _0801_ VGND VGND VPWR VPWR _0807_ sky130_fd_sc_hd__o211a_1
XFILLER_56_233 VGND VGND VPWR VPWR sky130_fd_sc_hd__fill_2
XFILLER_56_211 VGND VGND VPWR VPWR sky130_fd_sc_hd__decap_3
XFILLER_56_200 VGND VGND VPWR VPWR sky130_fd_sc_hd__decap_3
XFILLER_56_49 VGND VGND VPWR VPWR sky130_fd_sc_hd__decap_3
X_2439_ _0728_ _0731_ _0737_ VGND VGND VPWR VPWR _0738_ sky130_fd_sc_hd__a21oi_1
XTAP_TAPCELL_ROW_54_489 VGND VPWR sky130_fd_sc_hd__tapvpwrvgnd_1
XFILLER_47_200 VGND VGND VPWR VPWR sky130_fd_sc_hd__decap_3
XFILLER_62_225 VGND VGND VPWR VPWR sky130_fd_sc_hd__decap_3
XFILLER_62_203 VGND VGND VPWR VPWR sky130_fd_sc_hd__decap_3
XFILLER_46_60 VGND VGND VPWR VPWR sky130_fd_sc_hd__decap_3
X_1810_ _1341_ _1353_ VGND VGND VPWR VPWR _1354_ sky130_fd_sc_hd__nor2_1
X_1741_ _1259_ _1281_ _1283_ VGND VGND VPWR VPWR _1285_ sky130_fd_sc_hd__nor3_1
XFILLER_30_188 VGND VGND VPWR VPWR sky130_fd_sc_hd__decap_3
XFILLER_30_122 VGND VGND VPWR VPWR sky130_fd_sc_hd__decap_3
XFILLER_7_54 VGND VGND VPWR VPWR sky130_fd_sc_hd__fill_2
XFILLER_7_340 VGND VGND VPWR VPWR sky130_fd_sc_hd__decap_3
X_2790_ ss_s1 _1089_ _1093_ _1041_ VGND VGND VPWR VPWR _1042_ sky130_fd_sc_hd__o31a_1
X_1672_ my_mul.x2\[3\] acc_reg\[6\] acc_reg\[5\] my_mul.x2\[4\] VGND VGND VPWR VPWR
+ _1216_ sky130_fd_sc_hd__a22oi_1
Xhold307 acc_reg\[4\] VGND VGND VPWR VPWR net312 sky130_fd_sc_hd__dlygate4sd3_1
XFILLER_7_362 VGND VGND VPWR VPWR sky130_fd_sc_hd__decap_3
XFILLER_53_214 VGND VGND VPWR VPWR sky130_fd_sc_hd__decap_3
X_2224_ _0534_ _0558_ _0550_ VGND VGND VPWR VPWR _0559_ sky130_fd_sc_hd__o21a_1
X_2155_ net308 _0466_ _0504_ VGND VGND VPWR VPWR _0344_ sky130_fd_sc_hd__mux2_1
XFILLER_38_277 VGND VGND VPWR VPWR sky130_fd_sc_hd__fill_2
XFILLER_53_247 VGND VGND VPWR VPWR sky130_fd_sc_hd__decap_3
X_2086_ _1471_ _0459_ VGND VGND VPWR VPWR _0483_ sky130_fd_sc_hd__nand2_1
XFILLER_42_29 VGND VGND VPWR VPWR sky130_fd_sc_hd__decap_3
X_1939_ _1183_ _1420_ _1468_ VGND VGND VPWR VPWR _1483_ sky130_fd_sc_hd__a21boi_1
X_2988_ net2 VGND VGND VPWR VPWR _0084_ sky130_fd_sc_hd__inv_2
XFILLER_44_203 VGND VGND VPWR VPWR sky130_fd_sc_hd__decap_3
XFILLER_29_222 VGND VGND VPWR VPWR sky130_fd_sc_hd__fill_2
XPHY_EDGE_ROW_11_Right_11 VGND VGND VPWR VPWR sky130_fd_sc_hd__decap_3
XPHY_EDGE_ROW_20_Right_20 VGND VGND VPWR VPWR sky130_fd_sc_hd__decap_3
XFILLER_4_365 VGND VGND VPWR VPWR sky130_fd_sc_hd__decap_3
XTAP_TAPCELL_ROW_7_181 VGND VPWR sky130_fd_sc_hd__tapvpwrvgnd_1
XFILLER_50_239 VGND VGND VPWR VPWR sky130_fd_sc_hd__decap_3
XFILLER_50_217 VGND VGND VPWR VPWR sky130_fd_sc_hd__fill_1
X_2911_ net5 VGND VGND VPWR VPWR _0192_ sky130_fd_sc_hd__inv_2
XFILLER_35_225 VGND VGND VPWR VPWR sky130_fd_sc_hd__decap_3
X_1724_ _1264_ _1266_ _1267_ VGND VGND VPWR VPWR _1268_ sky130_fd_sc_hd__a21oi_1
Xhold126 my_sum_sub.al_mb\[5\] VGND VGND VPWR VPWR net131 sky130_fd_sc_hd__dlygate4sd3_1
Xhold115 _0335_ VGND VGND VPWR VPWR net120 sky130_fd_sc_hd__dlygate4sd3_1
X_2842_ net2 VGND VGND VPWR VPWR _0123_ sky130_fd_sc_hd__inv_2
X_2773_ net108 _1033_ _1037_ VGND VGND VPWR VPWR _0258_ sky130_fd_sc_hd__o21a_1
Xhold104 _0258_ VGND VGND VPWR VPWR net109 sky130_fd_sc_hd__dlygate4sd3_1
XFILLER_58_339 VGND VGND VPWR VPWR sky130_fd_sc_hd__decap_3
X_1655_ _1195_ _1198_ VGND VGND VPWR VPWR _1199_ sky130_fd_sc_hd__nand2_1
Xhold148 _0355_ VGND VGND VPWR VPWR net153 sky130_fd_sc_hd__dlygate4sd3_1
Xhold137 my_sum_sub.al_mb\[1\] VGND VGND VPWR VPWR net142 sky130_fd_sc_hd__dlygate4sd3_1
X_1586_ _1128_ _1129_ VGND VGND VPWR VPWR _1130_ sky130_fd_sc_hd__nor2_1
Xhold159 _0270_ VGND VGND VPWR VPWR net164 sky130_fd_sc_hd__dlygate4sd3_1
X_2207_ _0541_ VGND VGND VPWR VPWR _0542_ sky130_fd_sc_hd__inv_2
X_2069_ _1475_ _0462_ _0468_ VGND VGND VPWR VPWR _0469_ sky130_fd_sc_hd__a21oi_1
X_2138_ net152 my_mul.x2\[1\] _0500_ VGND VGND VPWR VPWR _0355_ sky130_fd_sc_hd__mux2_1
XFILLER_26_247 VGND VGND VPWR VPWR sky130_fd_sc_hd__decap_3
XFILLER_26_203 VGND VGND VPWR VPWR sky130_fd_sc_hd__decap_3
XFILLER_34_280 VGND VGND VPWR VPWR sky130_fd_sc_hd__fill_2
XFILLER_1_302 VGND VGND VPWR VPWR sky130_fd_sc_hd__decap_3
XFILLER_57_361 VGND VGND VPWR VPWR sky130_fd_sc_hd__decap_3
XPHY_EDGE_ROW_36_Left_99 VGND VGND VPWR VPWR sky130_fd_sc_hd__decap_3
XFILLER_1_368 VGND VGND VPWR VPWR sky130_fd_sc_hd__fill_2
XTAP_TAPCELL_ROW_4_162 VGND VPWR sky130_fd_sc_hd__tapvpwrvgnd_1
XFILLER_32_217 VGND VGND VPWR VPWR sky130_fd_sc_hd__fill_2
Xload_slew5 net2 VGND VGND VPWR VPWR net5 sky130_fd_sc_hd__clkbuf_16
X_3110_ clknet_4_1_0_clk _0206_ _0021_ VGND VGND VPWR VPWR my_mul.x2\[15\] sky130_fd_sc_hd__dfrtp_1
XTAP_TAPCELL_ROW_10_197 VGND VPWR sky130_fd_sc_hd__tapvpwrvgnd_1
XFILLER_48_361 VGND VGND VPWR VPWR sky130_fd_sc_hd__decap_3
X_3041_ clknet_4_15_0_clk _0300_ _0137_ VGND VGND VPWR VPWR my_sum_sub.al_ma\[0\]
+ sky130_fd_sc_hd__dfrtp_2
XTAP_TAPCELL_ROW_61_532 VGND VPWR sky130_fd_sc_hd__tapvpwrvgnd_1
XFILLER_23_217 VGND VGND VPWR VPWR sky130_fd_sc_hd__decap_3
X_2825_ net5 VGND VGND VPWR VPWR _0106_ sky130_fd_sc_hd__inv_2
XTAP_TAPCELL_ROW_18_253 VGND VPWR sky130_fd_sc_hd__tapvpwrvgnd_1
X_1707_ _1233_ _1240_ _1248_ VGND VGND VPWR VPWR _1251_ sky130_fd_sc_hd__nor3_1
X_1638_ _1168_ _1181_ _1165_ VGND VGND VPWR VPWR _1182_ sky130_fd_sc_hd__a21bo_1
X_2687_ net8 net276 net198 _0824_ VGND VGND VPWR VPWR _0971_ sky130_fd_sc_hd__a22o_1
X_2756_ net194 _0974_ _1024_ _0972_ _1025_ VGND VGND VPWR VPWR _0263_ sky130_fd_sc_hd__a221o_1
XFILLER_58_147 VGND VGND VPWR VPWR sky130_fd_sc_hd__fill_2
XFILLER_58_114 VGND VGND VPWR VPWR sky130_fd_sc_hd__decap_3
XFILLER_58_103 VGND VGND VPWR VPWR sky130_fd_sc_hd__decap_3
X_1569_ my_mul.x2\[11\] acc_reg\[11\] _1112_ VGND VGND VPWR VPWR _1113_ sky130_fd_sc_hd__a21oi_1
XTAP_TAPCELL_ROW_1_143 VGND VPWR sky130_fd_sc_hd__tapvpwrvgnd_1
XTAP_TAPCELL_ROW_24_289 VGND VPWR sky130_fd_sc_hd__tapvpwrvgnd_1
XFILLER_13_31 VGND VGND VPWR VPWR sky130_fd_sc_hd__decap_3
XFILLER_49_103 VGND VGND VPWR VPWR sky130_fd_sc_hd__decap_3
XFILLER_49_169 VGND VGND VPWR VPWR sky130_fd_sc_hd__fill_2
XFILLER_49_125 VGND VGND VPWR VPWR sky130_fd_sc_hd__fill_2
XFILLER_60_345 VGND VGND VPWR VPWR sky130_fd_sc_hd__decap_3
XFILLER_60_312 VGND VGND VPWR VPWR sky130_fd_sc_hd__decap_3
XFILLER_60_301 VGND VGND VPWR VPWR sky130_fd_sc_hd__decap_3
XFILLER_54_60 VGND VGND VPWR VPWR sky130_fd_sc_hd__decap_3
XTAP_TAPCELL_ROW_15_234 VGND VPWR sky130_fd_sc_hd__tapvpwrvgnd_1
Xclkload13 clknet_4_14_0_clk VGND VGND VPWR VPWR clkload13/Y sky130_fd_sc_hd__inv_12
X_2610_ _0705_ _0908_ VGND VGND VPWR VPWR _0909_ sky130_fd_sc_hd__and2_1
X_2541_ _0830_ _0838_ _0822_ _0828_ VGND VGND VPWR VPWR _0840_ sky130_fd_sc_hd__a211o_1
XFILLER_9_287 VGND VGND VPWR VPWR sky130_fd_sc_hd__decap_3
XFILLER_9_298 VGND VGND VPWR VPWR sky130_fd_sc_hd__decap_3
X_2472_ _0720_ _0748_ VGND VGND VPWR VPWR _0771_ sky130_fd_sc_hd__and2_1
XFILLER_48_3 VGND VGND VPWR VPWR sky130_fd_sc_hd__decap_3
X_3024_ clknet_4_10_0_clk _0283_ _0120_ VGND VGND VPWR VPWR my_sum_sub.result\[7\]
+ sky130_fd_sc_hd__dfrtp_1
XFILLER_50_29 VGND VGND VPWR VPWR sky130_fd_sc_hd__decap_3
X_2808_ net2 VGND VGND VPWR VPWR _0089_ sky130_fd_sc_hd__inv_2
Xclkload7 clknet_4_8_0_clk VGND VGND VPWR VPWR clkload7/Y sky130_fd_sc_hd__inv_12
XFILLER_59_38 VGND VGND VPWR VPWR sky130_fd_sc_hd__decap_3
XFILLER_59_27 VGND VGND VPWR VPWR sky130_fd_sc_hd__decap_3
X_2739_ net200 _1011_ _1002_ VGND VGND VPWR VPWR _1012_ sky130_fd_sc_hd__mux2_1
XFILLER_46_128 VGND VGND VPWR VPWR sky130_fd_sc_hd__fill_2
XFILLER_39_180 VGND VGND VPWR VPWR sky130_fd_sc_hd__fill_2
XTAP_TAPCELL_ROW_29_326 VGND VPWR sky130_fd_sc_hd__tapvpwrvgnd_1
XFILLER_54_194 VGND VGND VPWR VPWR sky130_fd_sc_hd__fill_2
XFILLER_54_150 VGND VGND VPWR VPWR sky130_fd_sc_hd__decap_3
XFILLER_24_85 VGND VGND VPWR VPWR sky130_fd_sc_hd__fill_2
XTAP_TAPCELL_ROW_12_215 VGND VPWR sky130_fd_sc_hd__tapvpwrvgnd_1
XFILLER_10_253 VGND VGND VPWR VPWR sky130_fd_sc_hd__decap_3
XFILLER_10_264 VGND VGND VPWR VPWR sky130_fd_sc_hd__fill_1
XFILLER_49_60 VGND VGND VPWR VPWR sky130_fd_sc_hd__decap_3
XFILLER_45_172 VGND VGND VPWR VPWR sky130_fd_sc_hd__decap_3
XFILLER_37_139 VGND VGND VPWR VPWR sky130_fd_sc_hd__decap_3
XFILLER_33_334 VGND VGND VPWR VPWR sky130_fd_sc_hd__fill_2
XFILLER_18_342 VGND VGND VPWR VPWR sky130_fd_sc_hd__decap_3
XFILLER_60_197 VGND VGND VPWR VPWR sky130_fd_sc_hd__decap_3
XFILLER_33_367 VGND VGND VPWR VPWR sky130_fd_sc_hd__decap_3
X_1972_ _1432_ _1434_ _1489_ _1428_ _1150_ VGND VGND VPWR VPWR _0381_ sky130_fd_sc_hd__o311ai_1
XPHY_EDGE_ROW_23_Left_86 VGND VGND VPWR VPWR sky130_fd_sc_hd__decap_3
XPHY_EDGE_ROW_49_Right_49 VGND VGND VPWR VPWR sky130_fd_sc_hd__decap_3
X_2524_ net8 my_sum_sub.cm_mant\[7\] VGND VGND VPWR VPWR _0823_ sky130_fd_sc_hd__nand2b_1
X_2455_ _0707_ _0735_ VGND VGND VPWR VPWR _0754_ sky130_fd_sc_hd__xor2_2
XPHY_EDGE_ROW_58_Right_58 VGND VGND VPWR VPWR sky130_fd_sc_hd__decap_3
XFILLER_45_29 VGND VGND VPWR VPWR sky130_fd_sc_hd__decap_3
XFILLER_28_139 VGND VGND VPWR VPWR sky130_fd_sc_hd__fill_1
X_2386_ net117 _1055_ _0606_ acc_reg\[12\] VGND VGND VPWR VPWR _0691_ sky130_fd_sc_hd__a22o_1
XFILLER_51_175 VGND VGND VPWR VPWR sky130_fd_sc_hd__decap_3
XFILLER_51_142 VGND VGND VPWR VPWR sky130_fd_sc_hd__decap_3
XFILLER_51_131 VGND VGND VPWR VPWR sky130_fd_sc_hd__fill_1
XTAP_TAPCELL_ROW_26_307 VGND VPWR sky130_fd_sc_hd__tapvpwrvgnd_1
X_3007_ clknet_4_2_0_clk net301 _0103_ VGND VGND VPWR VPWR my_divider.remainder_reg\[6\]
+ sky130_fd_sc_hd__dfrtp_1
XFILLER_59_242 VGND VGND VPWR VPWR sky130_fd_sc_hd__decap_3
XFILLER_10_43 VGND VGND VPWR VPWR sky130_fd_sc_hd__decap_3
XFILLER_59_275 VGND VGND VPWR VPWR sky130_fd_sc_hd__decap_3
XFILLER_27_172 VGND VGND VPWR VPWR sky130_fd_sc_hd__fill_1
XFILLER_27_150 VGND VGND VPWR VPWR sky130_fd_sc_hd__decap_3
XFILLER_19_74 VGND VGND VPWR VPWR sky130_fd_sc_hd__fill_1
XFILLER_15_312 VGND VGND VPWR VPWR sky130_fd_sc_hd__decap_3
XFILLER_15_345 VGND VGND VPWR VPWR sky130_fd_sc_hd__decap_3
XFILLER_51_72 VGND VGND VPWR VPWR sky130_fd_sc_hd__decap_3
XFILLER_42_197 VGND VGND VPWR VPWR sky130_fd_sc_hd__fill_2
XFILLER_35_73 VGND VGND VPWR VPWR sky130_fd_sc_hd__fill_2
XTAP_TAPCELL_ROW_40_398 VGND VPWR sky130_fd_sc_hd__tapvpwrvgnd_1
X_2240_ my_sum_sub.al_b_larger _0531_ _0569_ VGND VGND VPWR VPWR _0573_ sky130_fd_sc_hd__a21bo_1
X_2171_ my_sum_sub.cm_exp\[0\] net106 my_sum_sub.state\[1\] VGND VGND VPWR VPWR _0329_
+ sky130_fd_sc_hd__mux2_1
XFILLER_33_164 VGND VGND VPWR VPWR sky130_fd_sc_hd__decap_3
XFILLER_18_161 VGND VGND VPWR VPWR sky130_fd_sc_hd__decap_3
XFILLER_18_183 VGND VGND VPWR VPWR sky130_fd_sc_hd__fill_1
XFILLER_18_194 VGND VGND VPWR VPWR sky130_fd_sc_hd__fill_2
X_1886_ _1152_ _1429_ VGND VGND VPWR VPWR _1430_ sky130_fd_sc_hd__nor2_1
X_1955_ _0362_ _0363_ VGND VGND VPWR VPWR _0364_ sky130_fd_sc_hd__or2_4
XFILLER_21_348 VGND VGND VPWR VPWR sky130_fd_sc_hd__decap_3
X_2438_ _0709_ _0726_ _0730_ VGND VGND VPWR VPWR _0737_ sky130_fd_sc_hd__and3_1
X_2507_ _0802_ _0804_ _0765_ _0795_ _0799_ VGND VGND VPWR VPWR _0806_ sky130_fd_sc_hd__o2111ai_1
XFILLER_0_208 VGND VGND VPWR VPWR sky130_fd_sc_hd__decap_3
X_2369_ _0628_ _0633_ _0682_ VGND VGND VPWR VPWR _0683_ sky130_fd_sc_hd__and3_1
XFILLER_24_197 VGND VGND VPWR VPWR sky130_fd_sc_hd__fill_1
XFILLER_24_164 VGND VGND VPWR VPWR sky130_fd_sc_hd__decap_3
XFILLER_62_259 VGND VGND VPWR VPWR sky130_fd_sc_hd__decap_3
XFILLER_62_237 VGND VGND VPWR VPWR sky130_fd_sc_hd__decap_3
XFILLER_46_72 VGND VGND VPWR VPWR sky130_fd_sc_hd__decap_3
XFILLER_15_164 VGND VGND VPWR VPWR sky130_fd_sc_hd__decap_3
XFILLER_62_60 VGND VGND VPWR VPWR sky130_fd_sc_hd__decap_3
X_1671_ _1210_ _1214_ VGND VGND VPWR VPWR _1215_ sky130_fd_sc_hd__nand2_1
X_1740_ _1281_ _1283_ _1259_ VGND VGND VPWR VPWR _1284_ sky130_fd_sc_hd__o21a_1
Xhold308 _0342_ VGND VGND VPWR VPWR net313 sky130_fd_sc_hd__dlygate4sd3_1
XFILLER_30_178 VGND VGND VPWR VPWR sky130_fd_sc_hd__decap_3
XFILLER_30_156 VGND VGND VPWR VPWR sky130_fd_sc_hd__fill_2
X_2223_ my_sum_sub.al_mb\[3\] my_sum_sub.al_ma\[3\] _0557_ VGND VGND VPWR VPWR _0558_
+ sky130_fd_sc_hd__a21oi_1
X_2085_ net54 _1099_ _0481_ _0482_ VGND VGND VPWR VPWR _0226_ sky130_fd_sc_hd__o22a_1
XFILLER_38_223 VGND VGND VPWR VPWR sky130_fd_sc_hd__decap_3
X_2154_ net303 _0504_ _0506_ _0456_ VGND VGND VPWR VPWR _0345_ sky130_fd_sc_hd__o22a_1
XFILLER_61_281 VGND VGND VPWR VPWR sky130_fd_sc_hd__decap_3
XFILLER_21_178 VGND VGND VPWR VPWR sky130_fd_sc_hd__decap_3
X_2987_ net5 VGND VGND VPWR VPWR _0083_ sky130_fd_sc_hd__inv_2
X_1869_ _1257_ _1412_ _1255_ VGND VGND VPWR VPWR _1413_ sky130_fd_sc_hd__a21o_1
X_1938_ _1481_ VGND VGND VPWR VPWR _1482_ sky130_fd_sc_hd__inv_2
XTAP_TAPCELL_ROW_59_516 VGND VPWR sky130_fd_sc_hd__tapvpwrvgnd_1
XPHY_EDGE_ROW_10_Left_73 VGND VGND VPWR VPWR sky130_fd_sc_hd__decap_3
XFILLER_44_248 VGND VGND VPWR VPWR sky130_fd_sc_hd__decap_3
XFILLER_44_215 VGND VGND VPWR VPWR sky130_fd_sc_hd__decap_3
XTAP_TAPCELL_ROW_42_405 VGND VPWR sky130_fd_sc_hd__tapvpwrvgnd_1
XFILLER_29_267 VGND VGND VPWR VPWR sky130_fd_sc_hd__decap_3
XTAP_TAPCELL_ROW_50_460 VGND VPWR sky130_fd_sc_hd__tapvpwrvgnd_1
XFILLER_32_85 VGND VGND VPWR VPWR sky130_fd_sc_hd__decap_3
XFILLER_8_149 VGND VGND VPWR VPWR sky130_fd_sc_hd__fill_1
XFILLER_12_156 VGND VGND VPWR VPWR sky130_fd_sc_hd__decap_3
XFILLER_4_322 VGND VGND VPWR VPWR sky130_fd_sc_hd__fill_2
XFILLER_4_355 VGND VGND VPWR VPWR sky130_fd_sc_hd__decap_3
XFILLER_57_60 VGND VGND VPWR VPWR sky130_fd_sc_hd__decap_3
XFILLER_35_204 VGND VGND VPWR VPWR sky130_fd_sc_hd__decap_3
XTAP_TAPCELL_ROW_7_182 VGND VPWR sky130_fd_sc_hd__tapvpwrvgnd_1
X_2910_ net5 VGND VGND VPWR VPWR _0191_ sky130_fd_sc_hd__inv_2
X_2841_ net2 VGND VGND VPWR VPWR _0122_ sky130_fd_sc_hd__inv_2
X_1723_ my_mul.x2\[2\] acc_reg\[5\] VGND VGND VPWR VPWR _1267_ sky130_fd_sc_hd__and2_1
X_1654_ _1189_ _1194_ VGND VGND VPWR VPWR _1198_ sky130_fd_sc_hd__or2_1
Xhold127 _0313_ VGND VGND VPWR VPWR net132 sky130_fd_sc_hd__dlygate4sd3_1
Xhold149 my_sum_sub.al_mb\[3\] VGND VGND VPWR VPWR net154 sky130_fd_sc_hd__dlygate4sd3_1
Xhold116 shift_in\[0\] VGND VGND VPWR VPWR net121 sky130_fd_sc_hd__dlygate4sd3_1
Xhold138 _0309_ VGND VGND VPWR VPWR net143 sky130_fd_sc_hd__dlygate4sd3_1
Xhold105 my_mul.x2\[7\] VGND VGND VPWR VPWR net110 sky130_fd_sc_hd__dlygate4sd3_1
X_2772_ _1035_ _1037_ net144 VGND VGND VPWR VPWR _0259_ sky130_fd_sc_hd__mux2_1
XFILLER_58_318 VGND VGND VPWR VPWR sky130_fd_sc_hd__decap_3
XFILLER_58_307 VGND VGND VPWR VPWR sky130_fd_sc_hd__fill_1
X_2206_ _0509_ _0510_ VGND VGND VPWR VPWR _0541_ sky130_fd_sc_hd__or2_1
X_1585_ my_mul.x2\[9\] acc_reg\[9\] VGND VGND VPWR VPWR _1129_ sky130_fd_sc_hd__and2b_1
X_2068_ _0458_ _0463_ VGND VGND VPWR VPWR _0468_ sky130_fd_sc_hd__or2_1
X_2137_ net167 net180 _0500_ VGND VGND VPWR VPWR _0356_ sky130_fd_sc_hd__mux2_1
XFILLER_57_340 VGND VGND VPWR VPWR sky130_fd_sc_hd__decap_3
XFILLER_49_307 VGND VGND VPWR VPWR sky130_fd_sc_hd__fill_2
XTAP_TAPCELL_ROW_4_163 VGND VPWR sky130_fd_sc_hd__tapvpwrvgnd_1
XFILLER_43_51 VGND VGND VPWR VPWR sky130_fd_sc_hd__fill_2
XFILLER_40_251 VGND VGND VPWR VPWR sky130_fd_sc_hd__fill_1
XFILLER_43_84 VGND VGND VPWR VPWR sky130_fd_sc_hd__fill_1
XTAP_TAPCELL_ROW_10_198 VGND VPWR sky130_fd_sc_hd__tapvpwrvgnd_1
XFILLER_4_12 VGND VGND VPWR VPWR sky130_fd_sc_hd__fill_1
X_3040_ clknet_4_3_0_clk net177 _0136_ VGND VGND VPWR VPWR my_sum_sub.al_exp\[7\]
+ sky130_fd_sc_hd__dfrtp_1
XTAP_TAPCELL_ROW_18_254 VGND VPWR sky130_fd_sc_hd__tapvpwrvgnd_1
XTAP_TAPCELL_ROW_61_533 VGND VPWR sky130_fd_sc_hd__tapvpwrvgnd_1
X_2824_ net2 VGND VGND VPWR VPWR _0105_ sky130_fd_sc_hd__inv_2
XFILLER_16_292 VGND VGND VPWR VPWR sky130_fd_sc_hd__decap_3
X_1706_ _1243_ _1246_ _1244_ VGND VGND VPWR VPWR _1250_ sky130_fd_sc_hd__o21ba_1
X_1637_ _1165_ _1170_ _1180_ VGND VGND VPWR VPWR _1181_ sky130_fd_sc_hd__and3_1
X_2755_ acc_reg\[3\] _0364_ _0973_ VGND VGND VPWR VPWR _1025_ sky130_fd_sc_hd__and3_1
X_2686_ _0958_ _0961_ _0970_ net48 _1057_ VGND VGND VPWR VPWR _0277_ sky130_fd_sc_hd__a32o_1
XFILLER_58_159 VGND VGND VPWR VPWR sky130_fd_sc_hd__decap_3
XFILLER_58_126 VGND VGND VPWR VPWR sky130_fd_sc_hd__decap_3
X_1499_ my_sum_sub.al_b_larger VGND VGND VPWR VPWR _1054_ sky130_fd_sc_hd__inv_2
XFILLER_48_29 VGND VGND VPWR VPWR sky130_fd_sc_hd__decap_3
XFILLER_48_18 VGND VGND VPWR VPWR sky130_fd_sc_hd__fill_1
X_1568_ _1110_ _1111_ VGND VGND VPWR VPWR _1112_ sky130_fd_sc_hd__or2_2
X_3169_ clknet_4_1_0_clk net1 _0080_ VGND VGND VPWR VPWR mosi_s0 sky130_fd_sc_hd__dfrtp_1
XTAP_TAPCELL_ROW_1_144 VGND VPWR sky130_fd_sc_hd__tapvpwrvgnd_1
XFILLER_14_229 VGND VGND VPWR VPWR sky130_fd_sc_hd__fill_2
XFILLER_49_148 VGND VGND VPWR VPWR sky130_fd_sc_hd__decap_3
XFILLER_49_137 VGND VGND VPWR VPWR sky130_fd_sc_hd__decap_3
XFILLER_1_166 VGND VGND VPWR VPWR sky130_fd_sc_hd__fill_2
XFILLER_8_3 VGND VGND VPWR VPWR sky130_fd_sc_hd__decap_3
XFILLER_60_368 VGND VGND VPWR VPWR sky130_fd_sc_hd__fill_2
XFILLER_60_357 VGND VGND VPWR VPWR sky130_fd_sc_hd__decap_3
XFILLER_60_324 VGND VGND VPWR VPWR sky130_fd_sc_hd__decap_3
XFILLER_54_94 VGND VGND VPWR VPWR sky130_fd_sc_hd__decap_3
XFILLER_9_266 VGND VGND VPWR VPWR sky130_fd_sc_hd__decap_3
XTAP_TAPCELL_ROW_15_235 VGND VPWR sky130_fd_sc_hd__tapvpwrvgnd_1
XFILLER_62_6 VGND VGND VPWR VPWR sky130_fd_sc_hd__decap_3
Xclkload14 clknet_4_15_0_clk VGND VGND VPWR VPWR clkload14/Y sky130_fd_sc_hd__clkinv_8
X_2471_ my_sum_sub.cm_mant\[5\] _0743_ VGND VGND VPWR VPWR _0770_ sky130_fd_sc_hd__or2_2
X_2540_ _0821_ _0830_ _0838_ _0828_ VGND VGND VPWR VPWR _0839_ sky130_fd_sc_hd__a31o_1
XFILLER_55_118 VGND VGND VPWR VPWR sky130_fd_sc_hd__decap_3
X_3023_ clknet_4_10_0_clk _0282_ _0119_ VGND VGND VPWR VPWR my_sum_sub.result\[6\]
+ sky130_fd_sc_hd__dfrtp_1
XFILLER_36_354 VGND VGND VPWR VPWR sky130_fd_sc_hd__fill_2
Xclkload8 clknet_4_9_0_clk VGND VGND VPWR VPWR clkload8/Y sky130_fd_sc_hd__inv_16
X_2738_ _0996_ _1010_ VGND VGND VPWR VPWR _1011_ sky130_fd_sc_hd__nor2_1
X_2807_ net2 VGND VGND VPWR VPWR _0088_ sky130_fd_sc_hd__inv_2
X_2669_ _0917_ _0925_ _0933_ _0941_ VGND VGND VPWR VPWR _0959_ sky130_fd_sc_hd__or4_1
XFILLER_39_192 VGND VGND VPWR VPWR sky130_fd_sc_hd__decap_3
XFILLER_27_343 VGND VGND VPWR VPWR sky130_fd_sc_hd__decap_3
XFILLER_27_332 VGND VGND VPWR VPWR sky130_fd_sc_hd__decap_3
XFILLER_54_184 VGND VGND VPWR VPWR sky130_fd_sc_hd__decap_3
XFILLER_42_368 VGND VGND VPWR VPWR sky130_fd_sc_hd__fill_2
XTAP_TAPCELL_ROW_12_216 VGND VPWR sky130_fd_sc_hd__tapvpwrvgnd_1
XFILLER_10_276 VGND VGND VPWR VPWR sky130_fd_sc_hd__decap_3
XFILLER_49_83 VGND VGND VPWR VPWR sky130_fd_sc_hd__decap_3
XFILLER_60_121 VGND VGND VPWR VPWR sky130_fd_sc_hd__decap_3
XFILLER_45_151 VGND VGND VPWR VPWR sky130_fd_sc_hd__decap_3
XFILLER_33_324 VGND VGND VPWR VPWR sky130_fd_sc_hd__decap_3
XFILLER_60_3 VGND VGND VPWR VPWR sky130_fd_sc_hd__decap_3
X_1971_ _1425_ _1446_ _1447_ _0379_ VGND VGND VPWR VPWR _0380_ sky130_fd_sc_hd__or4_1
X_2385_ net119 _1055_ _0607_ net123 _0690_ VGND VGND VPWR VPWR _0298_ sky130_fd_sc_hd__a221o_1
X_2454_ _0707_ _0735_ VGND VGND VPWR VPWR _0753_ sky130_fd_sc_hd__nand2_1
X_2523_ _0818_ _0819_ _0759_ _0813_ VGND VGND VPWR VPWR _0822_ sky130_fd_sc_hd__or4bb_1
Xinput1 mosi VGND VGND VPWR VPWR net1 sky130_fd_sc_hd__clkbuf_1
X_3006_ clknet_4_2_0_clk net201 _0102_ VGND VGND VPWR VPWR my_divider.remainder_reg\[5\]
+ sky130_fd_sc_hd__dfrtp_1
XFILLER_61_18 VGND VGND VPWR VPWR sky130_fd_sc_hd__decap_3
XFILLER_51_187 VGND VGND VPWR VPWR sky130_fd_sc_hd__decap_3
XFILLER_51_154 VGND VGND VPWR VPWR sky130_fd_sc_hd__decap_3
XFILLER_51_110 VGND VGND VPWR VPWR sky130_fd_sc_hd__fill_2
XFILLER_36_195 VGND VGND VPWR VPWR sky130_fd_sc_hd__fill_1
XFILLER_24_368 VGND VGND VPWR VPWR sky130_fd_sc_hd__fill_2
XFILLER_59_287 VGND VGND VPWR VPWR sky130_fd_sc_hd__decap_3
XFILLER_59_254 VGND VGND VPWR VPWR sky130_fd_sc_hd__decap_3
XFILLER_59_221 VGND VGND VPWR VPWR sky130_fd_sc_hd__decap_3
XFILLER_42_154 VGND VGND VPWR VPWR sky130_fd_sc_hd__decap_3
XFILLER_35_85 VGND VGND VPWR VPWR sky130_fd_sc_hd__fill_1
XFILLER_15_324 VGND VGND VPWR VPWR sky130_fd_sc_hd__decap_3
XFILLER_51_40 VGND VGND VPWR VPWR sky130_fd_sc_hd__decap_3
XFILLER_42_165 VGND VGND VPWR VPWR sky130_fd_sc_hd__decap_3
XTAP_TAPCELL_ROW_48_444 VGND VPWR sky130_fd_sc_hd__tapvpwrvgnd_1
X_2170_ my_sum_sub.cm_exp\[1\] net113 my_sum_sub.state\[1\] VGND VGND VPWR VPWR _0330_
+ sky130_fd_sc_hd__mux2_1
XPHY_EDGE_ROW_38_Left_101 VGND VGND VPWR VPWR sky130_fd_sc_hd__decap_3
XFILLER_33_154 VGND VGND VPWR VPWR sky130_fd_sc_hd__fill_2
X_1954_ acc_reg\[14\] net258 acc_reg\[12\] acc_reg\[11\] VGND VGND VPWR VPWR _0363_
+ sky130_fd_sc_hd__or4_1
XPHY_EDGE_ROW_47_Left_110 VGND VGND VPWR VPWR sky130_fd_sc_hd__decap_3
X_1885_ _1116_ _1140_ _1427_ VGND VGND VPWR VPWR _1429_ sky130_fd_sc_hd__or3b_2
X_2368_ _0618_ _0681_ VGND VGND VPWR VPWR _0682_ sky130_fd_sc_hd__and2_1
X_2437_ _0725_ _0733_ _0732_ VGND VGND VPWR VPWR _0736_ sky130_fd_sc_hd__a21o_1
X_2506_ _0802_ _0804_ _0795_ _0799_ VGND VGND VPWR VPWR _0805_ sky130_fd_sc_hd__o211ai_4
XFILLER_56_246 VGND VGND VPWR VPWR sky130_fd_sc_hd__decap_3
X_2299_ _0611_ _0621_ _0407_ _0454_ VGND VGND VPWR VPWR _0622_ sky130_fd_sc_hd__o211a_2
XFILLER_21_87 VGND VGND VPWR VPWR sky130_fd_sc_hd__fill_1
XFILLER_47_279 VGND VGND VPWR VPWR sky130_fd_sc_hd__fill_1
XFILLER_47_246 VGND VGND VPWR VPWR sky130_fd_sc_hd__decap_3
XFILLER_46_51 VGND VGND VPWR VPWR sky130_fd_sc_hd__decap_3
XFILLER_46_40 VGND VGND VPWR VPWR sky130_fd_sc_hd__decap_3
XFILLER_62_249 VGND VGND VPWR VPWR sky130_fd_sc_hd__decap_3
XFILLER_62_216 VGND VGND VPWR VPWR sky130_fd_sc_hd__decap_3
XFILLER_62_50 VGND VGND VPWR VPWR sky130_fd_sc_hd__decap_3
XTAP_TAPCELL_ROW_53_480 VGND VPWR sky130_fd_sc_hd__tapvpwrvgnd_1
XTAP_TAPCELL_ROW_45_425 VGND VPWR sky130_fd_sc_hd__tapvpwrvgnd_1
XFILLER_30_113 VGND VGND VPWR VPWR sky130_fd_sc_hd__decap_3
XFILLER_62_94 VGND VGND VPWR VPWR sky130_fd_sc_hd__decap_3
XFILLER_62_83 VGND VGND VPWR VPWR sky130_fd_sc_hd__fill_1
X_1670_ _1211_ _1213_ VGND VGND VPWR VPWR _1214_ sky130_fd_sc_hd__or2_1
Xhold309 div_start VGND VGND VPWR VPWR net314 sky130_fd_sc_hd__dlygate4sd3_1
X_2222_ _0517_ _0518_ _0556_ VGND VGND VPWR VPWR _0557_ sky130_fd_sc_hd__a21oi_1
XFILLER_23_3 VGND VGND VPWR VPWR sky130_fd_sc_hd__fill_2
XFILLER_53_205 VGND VGND VPWR VPWR sky130_fd_sc_hd__decap_3
X_2084_ net44 _1064_ _1097_ acc_reg\[3\] _1100_ VGND VGND VPWR VPWR _0482_ sky130_fd_sc_hd__a221o_1
XFILLER_38_213 VGND VGND VPWR VPWR sky130_fd_sc_hd__decap_3
X_2153_ net294 _0504_ _0506_ _0451_ VGND VGND VPWR VPWR _0346_ sky130_fd_sc_hd__o22a_1
XFILLER_61_293 VGND VGND VPWR VPWR sky130_fd_sc_hd__decap_3
XFILLER_61_271 VGND VGND VPWR VPWR sky130_fd_sc_hd__decap_3
X_1937_ _1479_ _1480_ VGND VGND VPWR VPWR _1481_ sky130_fd_sc_hd__or2_1
X_2986_ net5 VGND VGND VPWR VPWR _0082_ sky130_fd_sc_hd__inv_2
X_1799_ my_mul.x2\[2\] acc_reg\[2\] VGND VGND VPWR VPWR _1343_ sky130_fd_sc_hd__nand2_1
X_1868_ _1286_ _1411_ _1284_ VGND VGND VPWR VPWR _1412_ sky130_fd_sc_hd__a21o_1
XTAP_TAPCELL_ROW_59_517 VGND VPWR sky130_fd_sc_hd__tapvpwrvgnd_1
XFILLER_29_279 VGND VGND VPWR VPWR sky130_fd_sc_hd__fill_1
XTAP_TAPCELL_ROW_42_406 VGND VPWR sky130_fd_sc_hd__tapvpwrvgnd_1
XFILLER_12_113 VGND VGND VPWR VPWR sky130_fd_sc_hd__fill_2
XTAP_TAPCELL_ROW_50_461 VGND VPWR sky130_fd_sc_hd__tapvpwrvgnd_1
XFILLER_4_301 VGND VGND VPWR VPWR sky130_fd_sc_hd__decap_3
XTAP_TAPCELL_ROW_7_183 VGND VPWR sky130_fd_sc_hd__tapvpwrvgnd_1
XFILLER_57_94 VGND VGND VPWR VPWR sky130_fd_sc_hd__decap_3
XFILLER_35_249 VGND VGND VPWR VPWR sky130_fd_sc_hd__decap_3
XFILLER_43_260 VGND VGND VPWR VPWR sky130_fd_sc_hd__fill_2
X_2771_ _0972_ _1036_ _1035_ VGND VGND VPWR VPWR _1037_ sky130_fd_sc_hd__o21ba_1
X_2840_ net2 VGND VGND VPWR VPWR _0121_ sky130_fd_sc_hd__inv_2
X_1722_ my_mul.x2\[4\] my_mul.x2\[3\] acc_reg\[4\] acc_reg\[3\] VGND VGND VPWR VPWR
+ _1266_ sky130_fd_sc_hd__nand4_1
X_1653_ my_mul.x2\[4\] acc_reg\[6\] my_mul.x2\[3\] VGND VGND VPWR VPWR _1197_ sky130_fd_sc_hd__a21oi_1
Xhold117 _0207_ VGND VGND VPWR VPWR net122 sky130_fd_sc_hd__dlygate4sd3_1
X_1584_ acc_reg\[9\] my_mul.x2\[9\] VGND VGND VPWR VPWR _1128_ sky130_fd_sc_hd__and2b_1
Xhold106 _0292_ VGND VGND VPWR VPWR net111 sky130_fd_sc_hd__dlygate4sd3_1
Xhold128 my_sum_sub.state\[3\] VGND VGND VPWR VPWR net133 sky130_fd_sc_hd__dlygate4sd3_1
Xhold139 my_divider.counter\[3\] VGND VGND VPWR VPWR net144 sky130_fd_sc_hd__dlygate4sd3_1
XFILLER_7_194 VGND VGND VPWR VPWR sky130_fd_sc_hd__decap_3
XPHY_EDGE_ROW_9_Right_9 VGND VGND VPWR VPWR sky130_fd_sc_hd__decap_3
X_2205_ _0539_ _0534_ VGND VGND VPWR VPWR _0540_ sky130_fd_sc_hd__and2b_1
X_2136_ net171 my_mul.x2\[3\] _0500_ VGND VGND VPWR VPWR _0357_ sky130_fd_sc_hd__mux2_1
X_2067_ net62 _1099_ _0466_ _0467_ VGND VGND VPWR VPWR _0229_ sky130_fd_sc_hd__o22a_1
XFILLER_26_216 VGND VGND VPWR VPWR sky130_fd_sc_hd__decap_3
X_2969_ net2 VGND VGND VPWR VPWR _0065_ sky130_fd_sc_hd__inv_2
XFILLER_1_359 VGND VGND VPWR VPWR sky130_fd_sc_hd__decap_3
XFILLER_57_352 VGND VGND VPWR VPWR sky130_fd_sc_hd__decap_3
XTAP_TAPCELL_ROW_4_164 VGND VPWR sky130_fd_sc_hd__tapvpwrvgnd_1
XFILLER_32_208 VGND VGND VPWR VPWR sky130_fd_sc_hd__decap_3
XFILLER_57_9 VGND VGND VPWR VPWR sky130_fd_sc_hd__decap_3
XTAP_TAPCELL_ROW_10_199 VGND VPWR sky130_fd_sc_hd__tapvpwrvgnd_1
XFILLER_4_197 VGND VGND VPWR VPWR sky130_fd_sc_hd__fill_2
XTAP_TAPCELL_ROW_61_534 VGND VPWR sky130_fd_sc_hd__tapvpwrvgnd_1
XTAP_TAPCELL_ROW_18_255 VGND VPWR sky130_fd_sc_hd__tapvpwrvgnd_1
X_1705_ _1240_ _1248_ _1233_ VGND VGND VPWR VPWR _1249_ sky130_fd_sc_hd__o21a_1
X_2823_ net2 VGND VGND VPWR VPWR _0104_ sky130_fd_sc_hd__inv_2
X_2754_ my_divider.remainder_reg\[2\] _1023_ _1002_ VGND VGND VPWR VPWR _1024_ sky130_fd_sc_hd__mux2_1
X_1636_ _1179_ VGND VGND VPWR VPWR _1180_ sky130_fd_sc_hd__inv_2
X_1567_ acc_reg\[12\] my_mul.x2\[12\] VGND VGND VPWR VPWR _1111_ sky130_fd_sc_hd__and2b_1
X_2685_ _0743_ _0947_ VGND VGND VPWR VPWR _0970_ sky130_fd_sc_hd__and2_1
XFILLER_58_138 VGND VGND VPWR VPWR sky130_fd_sc_hd__fill_2
X_2119_ net167 net152 net88 VGND VGND VPWR VPWR _0208_ sky130_fd_sc_hd__mux2_1
X_1498_ net23 VGND VGND VPWR VPWR _1053_ sky130_fd_sc_hd__inv_2
X_3168_ clknet_4_0_0_clk net29 _0079_ VGND VGND VPWR VPWR ss_s1 sky130_fd_sc_hd__dfstp_4
X_3099_ clknet_4_7_0_clk _0358_ _0195_ VGND VGND VPWR VPWR my_mul.x2\[4\] sky130_fd_sc_hd__dfrtp_4
XFILLER_22_230 VGND VGND VPWR VPWR sky130_fd_sc_hd__fill_2
XFILLER_49_116 VGND VGND VPWR VPWR sky130_fd_sc_hd__decap_3
XFILLER_60_336 VGND VGND VPWR VPWR sky130_fd_sc_hd__decap_3
XFILLER_57_182 VGND VGND VPWR VPWR sky130_fd_sc_hd__fill_1
XFILLER_45_344 VGND VGND VPWR VPWR sky130_fd_sc_hd__decap_3
XFILLER_38_85 VGND VGND VPWR VPWR sky130_fd_sc_hd__decap_3
XFILLER_9_223 VGND VGND VPWR VPWR sky130_fd_sc_hd__fill_1
XFILLER_9_278 VGND VGND VPWR VPWR sky130_fd_sc_hd__fill_2
XFILLER_55_6 VGND VGND VPWR VPWR sky130_fd_sc_hd__decap_3
X_2470_ my_sum_sub.cm_mant\[5\] _0743_ VGND VGND VPWR VPWR _0769_ sky130_fd_sc_hd__nor2_1
X_3022_ clknet_4_8_0_clk _0281_ _0118_ VGND VGND VPWR VPWR my_sum_sub.result\[5\]
+ sky130_fd_sc_hd__dfrtp_1
X_2737_ _0979_ _0980_ _0995_ VGND VGND VPWR VPWR _1010_ sky130_fd_sc_hd__nor3_1
X_2806_ net2 VGND VGND VPWR VPWR _0087_ sky130_fd_sc_hd__inv_2
Xclkload9 clknet_4_10_0_clk VGND VGND VPWR VPWR clkload9/Y sky130_fd_sc_hd__inv_12
X_2668_ _1057_ net193 _0926_ _0958_ VGND VGND VPWR VPWR _0283_ sky130_fd_sc_hd__a22o_1
XFILLER_59_18 VGND VGND VPWR VPWR sky130_fd_sc_hd__decap_3
X_1619_ my_mul.x2\[5\] _1161_ _1162_ VGND VGND VPWR VPWR _1163_ sky130_fd_sc_hd__and3_1
X_2599_ my_sum_sub.cm_mant\[4\] _0729_ net8 VGND VGND VPWR VPWR _0898_ sky130_fd_sc_hd__a21o_1
XFILLER_54_141 VGND VGND VPWR VPWR sky130_fd_sc_hd__decap_3
XFILLER_27_366 VGND VGND VPWR VPWR sky130_fd_sc_hd__decap_3
XFILLER_24_98 VGND VGND VPWR VPWR sky130_fd_sc_hd__decap_3
XFILLER_10_200 VGND VGND VPWR VPWR sky130_fd_sc_hd__decap_3
XFILLER_49_51 VGND VGND VPWR VPWR sky130_fd_sc_hd__decap_3
XFILLER_60_177 VGND VGND VPWR VPWR sky130_fd_sc_hd__decap_3
X_1970_ _1463_ _1475_ _1481_ _0378_ VGND VGND VPWR VPWR _0379_ sky130_fd_sc_hd__or4_2
XFILLER_45_163 VGND VGND VPWR VPWR sky130_fd_sc_hd__decap_3
XFILLER_45_130 VGND VGND VPWR VPWR sky130_fd_sc_hd__decap_3
XFILLER_33_358 VGND VGND VPWR VPWR sky130_fd_sc_hd__fill_1
XFILLER_53_3 VGND VGND VPWR VPWR sky130_fd_sc_hd__decap_3
X_2522_ _0818_ _0819_ _0759_ _0813_ VGND VGND VPWR VPWR _0821_ sky130_fd_sc_hd__and4bb_1
X_2384_ acc_reg\[13\] _0606_ VGND VGND VPWR VPWR _0690_ sky130_fd_sc_hd__and2_1
X_2453_ _0751_ _0748_ VGND VGND VPWR VPWR _0752_ sky130_fd_sc_hd__xnor2_2
XFILLER_36_141 VGND VGND VPWR VPWR sky130_fd_sc_hd__decap_3
Xinput2 rst VGND VGND VPWR VPWR net2 sky130_fd_sc_hd__clkbuf_16
X_3005_ clknet_4_2_0_clk net290 _0101_ VGND VGND VPWR VPWR my_divider.remainder_reg\[4\]
+ sky130_fd_sc_hd__dfrtp_1
XFILLER_51_199 VGND VGND VPWR VPWR sky130_fd_sc_hd__fill_2
XTAP_TAPCELL_ROW_34_353 VGND VPWR sky130_fd_sc_hd__tapvpwrvgnd_1
XFILLER_24_358 VGND VGND VPWR VPWR sky130_fd_sc_hd__decap_3
XFILLER_3_218 VGND VGND VPWR VPWR sky130_fd_sc_hd__decap_3
XFILLER_10_12 VGND VGND VPWR VPWR sky130_fd_sc_hd__decap_3
XFILLER_59_299 VGND VGND VPWR VPWR sky130_fd_sc_hd__decap_3
XFILLER_59_266 VGND VGND VPWR VPWR sky130_fd_sc_hd__decap_3
XFILLER_59_233 VGND VGND VPWR VPWR sky130_fd_sc_hd__decap_3
XFILLER_42_144 VGND VGND VPWR VPWR sky130_fd_sc_hd__decap_3
XFILLER_27_196 VGND VGND VPWR VPWR sky130_fd_sc_hd__decap_3
XFILLER_27_141 VGND VGND VPWR VPWR sky130_fd_sc_hd__decap_3
XFILLER_15_303 VGND VGND VPWR VPWR sky130_fd_sc_hd__decap_3
XFILLER_15_369 VGND VGND VPWR VPWR sky130_fd_sc_hd__fill_1
XFILLER_51_96 VGND VGND VPWR VPWR sky130_fd_sc_hd__fill_1
XFILLER_51_63 VGND VGND VPWR VPWR sky130_fd_sc_hd__decap_3
XFILLER_51_52 VGND VGND VPWR VPWR sky130_fd_sc_hd__decap_3
XFILLER_51_30 VGND VGND VPWR VPWR sky130_fd_sc_hd__decap_3
XFILLER_2_284 VGND VGND VPWR VPWR sky130_fd_sc_hd__decap_3
XTAP_TAPCELL_ROW_48_445 VGND VPWR sky130_fd_sc_hd__tapvpwrvgnd_1
XFILLER_33_111 VGND VGND VPWR VPWR sky130_fd_sc_hd__fill_1
X_1884_ _1116_ _1140_ _1152_ _1427_ VGND VGND VPWR VPWR _1428_ sky130_fd_sc_hd__or4b_1
XFILLER_33_199 VGND VGND VPWR VPWR sky130_fd_sc_hd__fill_2
XTAP_TAPCELL_ROW_31_334 VGND VPWR sky130_fd_sc_hd__tapvpwrvgnd_1
X_1953_ acc_reg\[10\] acc_reg\[9\] acc_reg\[8\] acc_reg\[7\] VGND VGND VPWR VPWR _0362_
+ sky130_fd_sc_hd__or4_1
X_2505_ _0783_ _0803_ _0786_ VGND VGND VPWR VPWR _0804_ sky130_fd_sc_hd__o21bai_4
XFILLER_56_214 VGND VGND VPWR VPWR sky130_fd_sc_hd__decap_3
XFILLER_56_203 VGND VGND VPWR VPWR sky130_fd_sc_hd__decap_3
XFILLER_56_19 VGND VGND VPWR VPWR sky130_fd_sc_hd__fill_1
X_2298_ _0604_ _0620_ VGND VGND VPWR VPWR _0621_ sky130_fd_sc_hd__and2_1
X_2367_ _0409_ _0436_ _0607_ _0620_ VGND VGND VPWR VPWR _0681_ sky130_fd_sc_hd__and4_2
X_2436_ _0725_ _0733_ VGND VGND VPWR VPWR _0735_ sky130_fd_sc_hd__nand2_1
XFILLER_2_90 VGND VGND VPWR VPWR sky130_fd_sc_hd__fill_1
XFILLER_21_44 VGND VGND VPWR VPWR sky130_fd_sc_hd__fill_1
XFILLER_20_361 VGND VGND VPWR VPWR sky130_fd_sc_hd__decap_3
XFILLER_62_228 VGND VGND VPWR VPWR sky130_fd_sc_hd__decap_3
XFILLER_62_206 VGND VGND VPWR VPWR sky130_fd_sc_hd__decap_3
XFILLER_47_225 VGND VGND VPWR VPWR sky130_fd_sc_hd__decap_3
XFILLER_47_203 VGND VGND VPWR VPWR sky130_fd_sc_hd__decap_3
XFILLER_46_85 VGND VGND VPWR VPWR sky130_fd_sc_hd__fill_2
XFILLER_46_63 VGND VGND VPWR VPWR sky130_fd_sc_hd__decap_3
XTAP_TAPCELL_ROW_45_426 VGND VPWR sky130_fd_sc_hd__tapvpwrvgnd_1
XTAP_TAPCELL_ROW_53_481 VGND VPWR sky130_fd_sc_hd__tapvpwrvgnd_1
XFILLER_30_125 VGND VGND VPWR VPWR sky130_fd_sc_hd__decap_3
XFILLER_7_13 VGND VGND VPWR VPWR sky130_fd_sc_hd__fill_2
XFILLER_7_321 VGND VGND VPWR VPWR sky130_fd_sc_hd__decap_3
XFILLER_7_343 VGND VGND VPWR VPWR sky130_fd_sc_hd__decap_3
XFILLER_7_365 VGND VGND VPWR VPWR sky130_fd_sc_hd__decap_3
X_2221_ _0536_ _0555_ _0552_ VGND VGND VPWR VPWR _0556_ sky130_fd_sc_hd__o21a_1
X_2152_ net292 _0504_ _0506_ _0445_ VGND VGND VPWR VPWR _0347_ sky130_fd_sc_hd__o22a_1
XFILLER_16_3 VGND VGND VPWR VPWR sky130_fd_sc_hd__decap_3
XFILLER_61_250 VGND VGND VPWR VPWR sky130_fd_sc_hd__decap_3
XFILLER_53_217 VGND VGND VPWR VPWR sky130_fd_sc_hd__decap_3
X_2083_ _0479_ _0480_ net280 VGND VGND VPWR VPWR _0481_ sky130_fd_sc_hd__o21a_1
XFILLER_38_258 VGND VGND VPWR VPWR sky130_fd_sc_hd__decap_3
XFILLER_21_103 VGND VGND VPWR VPWR sky130_fd_sc_hd__fill_1
X_1867_ _1315_ _1410_ _1313_ VGND VGND VPWR VPWR _1411_ sky130_fd_sc_hd__o21bai_1
X_1936_ _1183_ _1474_ VGND VGND VPWR VPWR _1480_ sky130_fd_sc_hd__and2_1
X_2985_ net2 VGND VGND VPWR VPWR _0081_ sky130_fd_sc_hd__inv_2
X_1798_ my_mul.x2\[4\] my_mul.x2\[3\] acc_reg\[1\] acc_reg\[0\] VGND VGND VPWR VPWR
+ _1342_ sky130_fd_sc_hd__and4_1
XTAP_TAPCELL_ROW_59_518 VGND VPWR sky130_fd_sc_hd__tapvpwrvgnd_1
XFILLER_44_206 VGND VGND VPWR VPWR sky130_fd_sc_hd__decap_3
X_2419_ _0716_ _0717_ VGND VGND VPWR VPWR _0718_ sky130_fd_sc_hd__nor2_1
XFILLER_52_250 VGND VGND VPWR VPWR sky130_fd_sc_hd__fill_2
XTAP_TAPCELL_ROW_42_407 VGND VPWR sky130_fd_sc_hd__tapvpwrvgnd_1
XTAP_TAPCELL_ROW_50_462 VGND VPWR sky130_fd_sc_hd__tapvpwrvgnd_1
XFILLER_4_368 VGND VGND VPWR VPWR sky130_fd_sc_hd__fill_2
XFILLER_50_209 VGND VGND VPWR VPWR sky130_fd_sc_hd__fill_2
XFILLER_35_228 VGND VGND VPWR VPWR sky130_fd_sc_hd__decap_3
X_1721_ my_mul.x2\[4\] my_mul.x2\[3\] acc_reg\[4\] acc_reg\[3\] VGND VGND VPWR VPWR
+ _1265_ sky130_fd_sc_hd__and4_1
XFILLER_43_294 VGND VGND VPWR VPWR sky130_fd_sc_hd__fill_1
X_2770_ net168 div_start VGND VGND VPWR VPWR _1036_ sky130_fd_sc_hd__nor2_1
XFILLER_11_180 VGND VGND VPWR VPWR sky130_fd_sc_hd__fill_2
Xhold129 my_sum_sub.al_mb\[7\] VGND VGND VPWR VPWR net134 sky130_fd_sc_hd__dlygate4sd3_1
X_1652_ my_mul.x2\[4\] my_mul.x2\[3\] acc_reg\[6\] VGND VGND VPWR VPWR _1196_ sky130_fd_sc_hd__and3_1
X_1583_ my_mul.x2\[7\] acc_reg\[7\] _1126_ VGND VGND VPWR VPWR _1127_ sky130_fd_sc_hd__o21a_1
Xhold118 my_mul.x2\[13\] VGND VGND VPWR VPWR net123 sky130_fd_sc_hd__dlygate4sd3_1
Xhold107 shift_in\[15\] VGND VGND VPWR VPWR net112 sky130_fd_sc_hd__dlygate4sd3_1
XFILLER_58_309 VGND VGND VPWR VPWR sky130_fd_sc_hd__decap_3
X_2204_ _0519_ _0535_ _0538_ _0528_ VGND VGND VPWR VPWR _0539_ sky130_fd_sc_hd__o31a_1
X_2135_ net190 net251 _0500_ VGND VGND VPWR VPWR _0358_ sky130_fd_sc_hd__mux2_1
XFILLER_26_206 VGND VGND VPWR VPWR sky130_fd_sc_hd__fill_1
X_2066_ net51 _1064_ _1097_ acc_reg\[6\] _1100_ VGND VGND VPWR VPWR _0467_ sky130_fd_sc_hd__a221o_1
X_1919_ _1451_ _1455_ _1462_ VGND VGND VPWR VPWR _1463_ sky130_fd_sc_hd__a21oi_1
X_2899_ net5 VGND VGND VPWR VPWR _0180_ sky130_fd_sc_hd__inv_2
X_2968_ net5 VGND VGND VPWR VPWR _0064_ sky130_fd_sc_hd__inv_2
XFILLER_57_320 VGND VGND VPWR VPWR sky130_fd_sc_hd__decap_3
XFILLER_1_305 VGND VGND VPWR VPWR sky130_fd_sc_hd__fill_2
XFILLER_57_364 VGND VGND VPWR VPWR sky130_fd_sc_hd__decap_3
XFILLER_27_98 VGND VGND VPWR VPWR sky130_fd_sc_hd__fill_2
XFILLER_40_253 VGND VGND VPWR VPWR sky130_fd_sc_hd__fill_2
XFILLER_4_36 VGND VGND VPWR VPWR sky130_fd_sc_hd__fill_2
XFILLER_16_250 VGND VGND VPWR VPWR sky130_fd_sc_hd__fill_2
X_1704_ _1242_ _1247_ VGND VGND VPWR VPWR _1248_ sky130_fd_sc_hd__nor2_1
X_2753_ _0993_ _1022_ VGND VGND VPWR VPWR _1023_ sky130_fd_sc_hd__nor2_1
X_2822_ net5 VGND VGND VPWR VPWR _0103_ sky130_fd_sc_hd__inv_2
X_2684_ _0958_ _0961_ _0969_ net33 _1057_ VGND VGND VPWR VPWR _0278_ sky130_fd_sc_hd__a32o_1
XFILLER_58_117 VGND VGND VPWR VPWR sky130_fd_sc_hd__decap_3
XFILLER_58_106 VGND VGND VPWR VPWR sky130_fd_sc_hd__fill_2
X_1635_ _1159_ _1171_ _1176_ _1178_ VGND VGND VPWR VPWR _1179_ sky130_fd_sc_hd__o31a_1
X_1497_ my_mul.x2\[7\] VGND VGND VPWR VPWR _1052_ sky130_fd_sc_hd__inv_2
X_1566_ my_mul.x2\[12\] acc_reg\[12\] VGND VGND VPWR VPWR _1110_ sky130_fd_sc_hd__and2b_1
XFILLER_54_312 VGND VGND VPWR VPWR sky130_fd_sc_hd__decap_3
X_3098_ clknet_4_7_0_clk net172 _0194_ VGND VGND VPWR VPWR my_mul.x2\[3\] sky130_fd_sc_hd__dfrtp_4
X_2118_ net171 net167 net88 VGND VGND VPWR VPWR _0209_ sky130_fd_sc_hd__mux2_1
X_2049_ shift_out\[9\] _1064_ _1097_ acc_reg\[8\] _1100_ VGND VGND VPWR VPWR _0452_
+ sky130_fd_sc_hd__a221o_1
X_3167_ clknet_4_0_0_clk net3 _0078_ VGND VGND VPWR VPWR ss_s0 sky130_fd_sc_hd__dfstp_1
XFILLER_22_264 VGND VGND VPWR VPWR sky130_fd_sc_hd__fill_1
XFILLER_1_124 VGND VGND VPWR VPWR sky130_fd_sc_hd__decap_3
XFILLER_49_106 VGND VGND VPWR VPWR sky130_fd_sc_hd__decap_3
XFILLER_60_348 VGND VGND VPWR VPWR sky130_fd_sc_hd__decap_3
XFILLER_60_315 VGND VGND VPWR VPWR sky130_fd_sc_hd__decap_3
XFILLER_60_304 VGND VGND VPWR VPWR sky130_fd_sc_hd__decap_3
XFILLER_54_85 VGND VGND VPWR VPWR sky130_fd_sc_hd__decap_3
XFILLER_54_63 VGND VGND VPWR VPWR sky130_fd_sc_hd__decap_3
XFILLER_13_286 VGND VGND VPWR VPWR sky130_fd_sc_hd__decap_3
XFILLER_48_6 VGND VGND VPWR VPWR sky130_fd_sc_hd__decap_3
X_3021_ clknet_4_8_0_clk _0280_ _0117_ VGND VGND VPWR VPWR my_sum_sub.result\[4\]
+ sky130_fd_sc_hd__dfrtp_1
XFILLER_51_359 VGND VGND VPWR VPWR sky130_fd_sc_hd__decap_3
X_2805_ net2 VGND VGND VPWR VPWR _0086_ sky130_fd_sc_hd__inv_2
X_1618_ my_mul.x2\[6\] acc_reg\[6\] acc_reg\[5\] VGND VGND VPWR VPWR _1162_ sky130_fd_sc_hd__a21o_1
X_2736_ _0972_ _1008_ net286 VGND VGND VPWR VPWR _0267_ sky130_fd_sc_hd__a21o_1
X_2667_ _1057_ net170 _0942_ _0958_ VGND VGND VPWR VPWR _0284_ sky130_fd_sc_hd__a22o_1
X_1549_ state\[4\] _1088_ _1093_ VGND VGND VPWR VPWR _1094_ sky130_fd_sc_hd__and3_1
X_2598_ _0896_ VGND VGND VPWR VPWR _0897_ sky130_fd_sc_hd__inv_2
XFILLER_54_197 VGND VGND VPWR VPWR sky130_fd_sc_hd__decap_3
XFILLER_54_153 VGND VGND VPWR VPWR sky130_fd_sc_hd__decap_3
XTAP_TAPCELL_ROW_37_373 VGND VPWR sky130_fd_sc_hd__tapvpwrvgnd_1
XFILLER_40_43 VGND VGND VPWR VPWR sky130_fd_sc_hd__fill_2
XTAP_TAPCELL_ROW_20_262 VGND VPWR sky130_fd_sc_hd__tapvpwrvgnd_1
XFILLER_10_256 VGND VGND VPWR VPWR sky130_fd_sc_hd__decap_3
XFILLER_49_63 VGND VGND VPWR VPWR sky130_fd_sc_hd__decap_3
Xhold290 acc_reg\[14\] VGND VGND VPWR VPWR net295 sky130_fd_sc_hd__dlygate4sd3_1
XFILLER_18_345 VGND VGND VPWR VPWR sky130_fd_sc_hd__decap_3
XFILLER_60_156 VGND VGND VPWR VPWR sky130_fd_sc_hd__decap_3
XFILLER_60_134 VGND VGND VPWR VPWR sky130_fd_sc_hd__decap_3
XFILLER_33_315 VGND VGND VPWR VPWR sky130_fd_sc_hd__fill_1
XFILLER_33_304 VGND VGND VPWR VPWR sky130_fd_sc_hd__fill_2
X_2521_ _0790_ _0807_ _0819_ VGND VGND VPWR VPWR _0820_ sky130_fd_sc_hd__or3_2
XFILLER_46_3 VGND VGND VPWR VPWR sky130_fd_sc_hd__decap_3
XFILLER_28_109 VGND VGND VPWR VPWR sky130_fd_sc_hd__fill_2
X_2383_ net176 _1145_ my_sum_sub.state\[2\] VGND VGND VPWR VPWR _0299_ sky130_fd_sc_hd__mux2_1
XFILLER_5_293 VGND VGND VPWR VPWR sky130_fd_sc_hd__decap_3
X_2452_ _0719_ _0715_ _0750_ VGND VGND VPWR VPWR _0751_ sky130_fd_sc_hd__mux2_1
XPHY_EDGE_ROW_18_Right_18 VGND VGND VPWR VPWR sky130_fd_sc_hd__decap_3
XFILLER_51_145 VGND VGND VPWR VPWR sky130_fd_sc_hd__decap_3
XFILLER_36_197 VGND VGND VPWR VPWR sky130_fd_sc_hd__decap_3
XPHY_EDGE_ROW_27_Right_27 VGND VGND VPWR VPWR sky130_fd_sc_hd__decap_3
XFILLER_24_348 VGND VGND VPWR VPWR sky130_fd_sc_hd__fill_1
X_3004_ clknet_4_10_0_clk net195 _0100_ VGND VGND VPWR VPWR my_divider.remainder_reg\[3\]
+ sky130_fd_sc_hd__dfrtp_1
Xinput3 ss VGND VGND VPWR VPWR net3 sky130_fd_sc_hd__clkbuf_1
XFILLER_51_178 VGND VGND VPWR VPWR sky130_fd_sc_hd__decap_3
XFILLER_51_167 VGND VGND VPWR VPWR sky130_fd_sc_hd__fill_1
XTAP_TAPCELL_ROW_34_354 VGND VPWR sky130_fd_sc_hd__tapvpwrvgnd_1
XFILLER_59_212 VGND VGND VPWR VPWR sky130_fd_sc_hd__decap_3
XPHY_EDGE_ROW_36_Right_36 VGND VGND VPWR VPWR sky130_fd_sc_hd__decap_3
X_2719_ _0983_ _0994_ _0982_ VGND VGND VPWR VPWR _0995_ sky130_fd_sc_hd__o21a_1
XFILLER_10_46 VGND VGND VPWR VPWR sky130_fd_sc_hd__decap_3
XFILLER_59_278 VGND VGND VPWR VPWR sky130_fd_sc_hd__fill_2
XFILLER_59_245 VGND VGND VPWR VPWR sky130_fd_sc_hd__decap_3
XFILLER_27_153 VGND VGND VPWR VPWR sky130_fd_sc_hd__decap_3
XPHY_EDGE_ROW_45_Right_45 VGND VGND VPWR VPWR sky130_fd_sc_hd__decap_3
XFILLER_35_54 VGND VGND VPWR VPWR sky130_fd_sc_hd__fill_2
XFILLER_30_307 VGND VGND VPWR VPWR sky130_fd_sc_hd__fill_1
XFILLER_15_315 VGND VGND VPWR VPWR sky130_fd_sc_hd__decap_3
XFILLER_15_337 VGND VGND VPWR VPWR sky130_fd_sc_hd__decap_3
XFILLER_15_348 VGND VGND VPWR VPWR sky130_fd_sc_hd__decap_3
XPHY_EDGE_ROW_54_Right_54 VGND VGND VPWR VPWR sky130_fd_sc_hd__decap_3
XFILLER_51_75 VGND VGND VPWR VPWR sky130_fd_sc_hd__decap_3
XTAP_TAPCELL_ROW_48_446 VGND VPWR sky130_fd_sc_hd__tapvpwrvgnd_1
XFILLER_33_123 VGND VGND VPWR VPWR sky130_fd_sc_hd__decap_3
XFILLER_18_164 VGND VGND VPWR VPWR sky130_fd_sc_hd__decap_3
XFILLER_18_197 VGND VGND VPWR VPWR sky130_fd_sc_hd__fill_2
X_1883_ _1426_ _1122_ _1121_ _1134_ VGND VGND VPWR VPWR _1427_ sky130_fd_sc_hd__and4bb_1
X_1952_ _1493_ _0359_ _0360_ VGND VGND VPWR VPWR _0361_ sky130_fd_sc_hd__or3_1
XFILLER_33_167 VGND VGND VPWR VPWR sky130_fd_sc_hd__fill_1
XTAP_TAPCELL_ROW_31_335 VGND VPWR sky130_fd_sc_hd__tapvpwrvgnd_1
X_2435_ my_sum_sub.cm_exp\[1\] my_sum_sub.cm_exp\[0\] net20 my_sum_sub.cm_mant\[7\]
+ VGND VGND VPWR VPWR _0734_ sky130_fd_sc_hd__or4_1
X_2504_ _0752_ _0775_ _0791_ VGND VGND VPWR VPWR _0803_ sky130_fd_sc_hd__and3b_1
X_2366_ _1055_ net207 _0364_ _0606_ VGND VGND VPWR VPWR _0307_ sky130_fd_sc_hd__a22o_1
X_2297_ _0416_ _0424_ _0430_ VGND VGND VPWR VPWR _0620_ sky130_fd_sc_hd__and3_1
XFILLER_24_167 VGND VGND VPWR VPWR sky130_fd_sc_hd__decap_3
XFILLER_24_101 VGND VGND VPWR VPWR sky130_fd_sc_hd__fill_2
XFILLER_21_34 VGND VGND VPWR VPWR sky130_fd_sc_hd__fill_1
XFILLER_46_75 VGND VGND VPWR VPWR sky130_fd_sc_hd__decap_3
XTAP_TAPCELL_ROW_45_427 VGND VPWR sky130_fd_sc_hd__tapvpwrvgnd_1
XFILLER_62_85 VGND VGND VPWR VPWR sky130_fd_sc_hd__decap_3
XFILLER_62_63 VGND VGND VPWR VPWR sky130_fd_sc_hd__decap_3
XFILLER_62_41 VGND VGND VPWR VPWR sky130_fd_sc_hd__decap_3
XTAP_TAPCELL_ROW_53_482 VGND VPWR sky130_fd_sc_hd__tapvpwrvgnd_1
XFILLER_30_137 VGND VGND VPWR VPWR sky130_fd_sc_hd__decap_3
XFILLER_7_333 VGND VGND VPWR VPWR sky130_fd_sc_hd__decap_3
XFILLER_11_340 VGND VGND VPWR VPWR sky130_fd_sc_hd__decap_3
XFILLER_15_167 VGND VGND VPWR VPWR sky130_fd_sc_hd__fill_1
XFILLER_7_47 VGND VGND VPWR VPWR sky130_fd_sc_hd__fill_1
X_2220_ net142 net216 _0554_ VGND VGND VPWR VPWR _0555_ sky130_fd_sc_hd__a21oi_1
XFILLER_38_204 VGND VGND VPWR VPWR sky130_fd_sc_hd__decap_3
X_2151_ net266 _0504_ _0506_ _0439_ VGND VGND VPWR VPWR _0348_ sky130_fd_sc_hd__o22a_1
X_2082_ net89 _1088_ _1090_ net37 VGND VGND VPWR VPWR _0480_ sky130_fd_sc_hd__a22o_1
XFILLER_61_284 VGND VGND VPWR VPWR sky130_fd_sc_hd__decap_3
XFILLER_61_262 VGND VGND VPWR VPWR sky130_fd_sc_hd__decap_3
X_2984_ net2 VGND VGND VPWR VPWR _0080_ sky130_fd_sc_hd__inv_2
X_1797_ _1326_ _1332_ VGND VGND VPWR VPWR _1341_ sky130_fd_sc_hd__xnor2_1
X_1866_ _1408_ _1409_ _1339_ VGND VGND VPWR VPWR _1410_ sky130_fd_sc_hd__o21ba_1
X_1935_ _1183_ _1420_ _1421_ VGND VGND VPWR VPWR _1479_ sky130_fd_sc_hd__and3b_1
XTAP_TAPCELL_ROW_59_519 VGND VPWR sky130_fd_sc_hd__tapvpwrvgnd_1
X_2418_ net18 net13 _0699_ my_sum_sub.cm_exp\[5\] VGND VGND VPWR VPWR _0717_ sky130_fd_sc_hd__a31oi_2
X_2349_ my_sum_sub.state\[2\] net140 _0666_ VGND VGND VPWR VPWR _0310_ sky130_fd_sc_hd__o21a_1
XFILLER_16_12 VGND VGND VPWR VPWR sky130_fd_sc_hd__decap_3
XTAP_TAPCELL_ROW_50_463 VGND VPWR sky130_fd_sc_hd__tapvpwrvgnd_1
XTAP_TAPCELL_ROW_42_408 VGND VPWR sky130_fd_sc_hd__tapvpwrvgnd_1
XPHY_EDGE_ROW_0_Right_0 VGND VGND VPWR VPWR sky130_fd_sc_hd__decap_3
XFILLER_32_88 VGND VGND VPWR VPWR sky130_fd_sc_hd__fill_1
XFILLER_4_358 VGND VGND VPWR VPWR sky130_fd_sc_hd__decap_3
XFILLER_57_63 VGND VGND VPWR VPWR sky130_fd_sc_hd__decap_3
XFILLER_43_284 VGND VGND VPWR VPWR sky130_fd_sc_hd__decap_3
XFILLER_35_207 VGND VGND VPWR VPWR sky130_fd_sc_hd__decap_3
X_1720_ my_mul.x2\[3\] acc_reg\[4\] acc_reg\[3\] my_mul.x2\[4\] VGND VGND VPWR VPWR
+ _1264_ sky130_fd_sc_hd__a22o_1
X_1651_ _1189_ _1194_ VGND VGND VPWR VPWR _1195_ sky130_fd_sc_hd__nand2_1
Xhold108 my_sum_sub.al_exp\[1\] VGND VGND VPWR VPWR net113 sky130_fd_sc_hd__dlygate4sd3_1
X_1582_ _1124_ _1125_ VGND VGND VPWR VPWR _1126_ sky130_fd_sc_hd__nand2b_2
Xhold119 _0298_ VGND VGND VPWR VPWR net124 sky130_fd_sc_hd__dlygate4sd3_1
X_2065_ _0464_ _0465_ net280 VGND VGND VPWR VPWR _0466_ sky130_fd_sc_hd__o21a_1
X_2203_ _0522_ _0537_ VGND VGND VPWR VPWR _0538_ sky130_fd_sc_hd__nand2_1
X_2134_ net235 net255 _0500_ VGND VGND VPWR VPWR _0196_ sky130_fd_sc_hd__mux2_1
XFILLER_34_262 VGND VGND VPWR VPWR sky130_fd_sc_hd__decap_3
XPHY_EDGE_ROW_14_Left_77 VGND VGND VPWR VPWR sky130_fd_sc_hd__decap_3
X_2967_ net2 VGND VGND VPWR VPWR _0063_ sky130_fd_sc_hd__inv_2
X_1849_ _1386_ _1392_ VGND VGND VPWR VPWR _1393_ sky130_fd_sc_hd__nor2_1
X_1918_ _1423_ _1448_ _1450_ _1460_ VGND VGND VPWR VPWR _1462_ sky130_fd_sc_hd__o211a_1
X_2898_ net5 VGND VGND VPWR VPWR _0179_ sky130_fd_sc_hd__inv_2
XFILLER_57_343 VGND VGND VPWR VPWR sky130_fd_sc_hd__decap_3
XFILLER_57_332 VGND VGND VPWR VPWR sky130_fd_sc_hd__decap_3
XFILLER_43_65 VGND VGND VPWR VPWR sky130_fd_sc_hd__fill_2
XFILLER_40_276 VGND VGND VPWR VPWR sky130_fd_sc_hd__decap_3
XFILLER_40_232 VGND VGND VPWR VPWR sky130_fd_sc_hd__fill_2
XFILLER_40_221 VGND VGND VPWR VPWR sky130_fd_sc_hd__decap_3
XFILLER_48_343 VGND VGND VPWR VPWR sky130_fd_sc_hd__decap_3
XFILLER_0_361 VGND VGND VPWR VPWR sky130_fd_sc_hd__decap_3
X_2821_ net2 VGND VGND VPWR VPWR _0102_ sky130_fd_sc_hd__inv_2
XFILLER_16_295 VGND VGND VPWR VPWR sky130_fd_sc_hd__decap_3
X_1703_ _1245_ _1246_ VGND VGND VPWR VPWR _1247_ sky130_fd_sc_hd__xnor2_1
X_1634_ my_mul.x2\[4\] _1177_ VGND VGND VPWR VPWR _1178_ sky130_fd_sc_hd__nand2_1
X_2683_ _0743_ _0893_ _0968_ VGND VGND VPWR VPWR _0969_ sky130_fd_sc_hd__a21o_1
X_2752_ _0988_ _0989_ _0992_ VGND VGND VPWR VPWR _1022_ sky130_fd_sc_hd__nor3_1
XFILLER_58_129 VGND VGND VPWR VPWR sky130_fd_sc_hd__decap_3
X_1496_ my_mul.x2\[11\] VGND VGND VPWR VPWR _1051_ sky130_fd_sc_hd__inv_2
X_1565_ _1107_ _1108_ VGND VGND VPWR VPWR _1109_ sky130_fd_sc_hd__xnor2_1
XFILLER_54_368 VGND VGND VPWR VPWR sky130_fd_sc_hd__fill_2
X_3097_ clknet_4_7_0_clk _0356_ _0193_ VGND VGND VPWR VPWR my_mul.x2\[2\] sky130_fd_sc_hd__dfrtp_4
X_2117_ net190 net171 net88 VGND VGND VPWR VPWR _0210_ sky130_fd_sc_hd__mux2_1
X_2048_ net170 _1091_ _0450_ net280 VGND VGND VPWR VPWR _0451_ sky130_fd_sc_hd__o211a_1
X_3166_ clknet_4_0_0_clk net30 _0077_ VGND VGND VPWR VPWR sclk_s1 sky130_fd_sc_hd__dfrtp_1
XFILLER_8_6 VGND VGND VPWR VPWR sky130_fd_sc_hd__decap_3
XFILLER_38_65 VGND VGND VPWR VPWR sky130_fd_sc_hd__fill_2
XFILLER_38_32 VGND VGND VPWR VPWR sky130_fd_sc_hd__fill_1
XFILLER_60_327 VGND VGND VPWR VPWR sky130_fd_sc_hd__decap_3
XFILLER_54_97 VGND VGND VPWR VPWR sky130_fd_sc_hd__decap_3
XFILLER_54_75 VGND VGND VPWR VPWR sky130_fd_sc_hd__decap_3
XFILLER_62_9 VGND VGND VPWR VPWR sky130_fd_sc_hd__decap_3
XTAP_TAPCELL_ROW_23_282 VGND VPWR sky130_fd_sc_hd__tapvpwrvgnd_1
XFILLER_48_195 VGND VGND VPWR VPWR sky130_fd_sc_hd__fill_1
XFILLER_48_151 VGND VGND VPWR VPWR sky130_fd_sc_hd__fill_2
XFILLER_36_368 VGND VGND VPWR VPWR sky130_fd_sc_hd__fill_2
XFILLER_36_324 VGND VGND VPWR VPWR sky130_fd_sc_hd__fill_2
X_3020_ clknet_4_8_0_clk _0279_ _0116_ VGND VGND VPWR VPWR my_sum_sub.result\[3\]
+ sky130_fd_sc_hd__dfrtp_1
X_2804_ net224 _1060_ net182 VGND VGND VPWR VPWR _0002_ sky130_fd_sc_hd__and3b_1
X_1617_ my_mul.x2\[6\] acc_reg\[6\] acc_reg\[5\] VGND VGND VPWR VPWR _1161_ sky130_fd_sc_hd__nand3_1
X_2666_ _1057_ net169 _0918_ _0958_ VGND VGND VPWR VPWR _0285_ sky130_fd_sc_hd__a22o_1
XFILLER_5_91 VGND VGND VPWR VPWR sky130_fd_sc_hd__fill_1
X_2735_ _0364_ _0973_ _0974_ net285 VGND VGND VPWR VPWR _1009_ sky130_fd_sc_hd__a22o_1
XFILLER_8_291 VGND VGND VPWR VPWR sky130_fd_sc_hd__decap_3
X_2597_ _0769_ _0798_ _0853_ _0895_ VGND VGND VPWR VPWR _0896_ sky130_fd_sc_hd__a31o_1
XFILLER_39_195 VGND VGND VPWR VPWR sky130_fd_sc_hd__decap_3
XFILLER_27_335 VGND VGND VPWR VPWR sky130_fd_sc_hd__fill_1
X_1548_ net108 my_divider.counter\[1\] my_divider.counter\[0\] net144 VGND VGND VPWR
+ VPWR _1093_ sky130_fd_sc_hd__or4b_1
X_3149_ clknet_4_1_0_clk net236 _0060_ VGND VGND VPWR VPWR op_reg\[1\] sky130_fd_sc_hd__dfrtp_1
XFILLER_54_187 VGND VGND VPWR VPWR sky130_fd_sc_hd__fill_1
XFILLER_50_360 VGND VGND VPWR VPWR sky130_fd_sc_hd__decap_3
XFILLER_42_349 VGND VGND VPWR VPWR sky130_fd_sc_hd__decap_3
XTAP_TAPCELL_ROW_37_374 VGND VPWR sky130_fd_sc_hd__tapvpwrvgnd_1
XFILLER_27_346 VGND VGND VPWR VPWR sky130_fd_sc_hd__decap_3
XFILLER_24_56 VGND VGND VPWR VPWR sky130_fd_sc_hd__decap_3
XFILLER_24_23 VGND VGND VPWR VPWR sky130_fd_sc_hd__decap_3
XFILLER_24_78 VGND VGND VPWR VPWR sky130_fd_sc_hd__decap_3
XTAP_TAPCELL_ROW_20_263 VGND VPWR sky130_fd_sc_hd__tapvpwrvgnd_1
XFILLER_10_224 VGND VGND VPWR VPWR sky130_fd_sc_hd__decap_3
XFILLER_10_235 VGND VGND VPWR VPWR sky130_fd_sc_hd__fill_1
XFILLER_10_279 VGND VGND VPWR VPWR sky130_fd_sc_hd__decap_3
XPHY_EDGE_ROW_17_Left_80 VGND VGND VPWR VPWR sky130_fd_sc_hd__decap_3
XFILLER_49_86 VGND VGND VPWR VPWR sky130_fd_sc_hd__decap_3
XFILLER_49_75 VGND VGND VPWR VPWR sky130_fd_sc_hd__fill_1
XFILLER_49_42 VGND VGND VPWR VPWR sky130_fd_sc_hd__fill_1
Xhold280 my_divider.remainder_reg\[7\] VGND VGND VPWR VPWR net285 sky130_fd_sc_hd__dlygate4sd3_1
Xhold291 _0352_ VGND VGND VPWR VPWR net296 sky130_fd_sc_hd__dlygate4sd3_1
XFILLER_45_154 VGND VGND VPWR VPWR sky130_fd_sc_hd__decap_3
XFILLER_33_327 VGND VGND VPWR VPWR sky130_fd_sc_hd__decap_3
XFILLER_1_27 VGND VGND VPWR VPWR sky130_fd_sc_hd__fill_1
XFILLER_18_357 VGND VGND VPWR VPWR sky130_fd_sc_hd__fill_1
XFILLER_60_124 VGND VGND VPWR VPWR sky130_fd_sc_hd__fill_1
XFILLER_60_6 VGND VGND VPWR VPWR sky130_fd_sc_hd__decap_3
X_2451_ _0749_ _0725_ VGND VGND VPWR VPWR _0750_ sky130_fd_sc_hd__and2b_1
X_2520_ _0763_ _0789_ _0806_ VGND VGND VPWR VPWR _0819_ sky130_fd_sc_hd__and3_1
XFILLER_39_3 VGND VGND VPWR VPWR sky130_fd_sc_hd__decap_3
X_2382_ _1055_ net273 _0679_ _0681_ _0689_ VGND VGND VPWR VPWR _0300_ sky130_fd_sc_hd__a221o_1
X_3003_ clknet_4_10_0_clk _0262_ _0099_ VGND VGND VPWR VPWR my_divider.remainder_reg\[2\]
+ sky130_fd_sc_hd__dfrtp_1
XFILLER_51_157 VGND VGND VPWR VPWR sky130_fd_sc_hd__decap_3
XFILLER_51_113 VGND VGND VPWR VPWR sky130_fd_sc_hd__decap_3
XTAP_TAPCELL_ROW_34_355 VGND VPWR sky130_fd_sc_hd__tapvpwrvgnd_1
X_2718_ _0986_ _0993_ _0985_ VGND VGND VPWR VPWR _0994_ sky130_fd_sc_hd__o21a_1
X_2649_ _0742_ _0852_ _0947_ _0770_ _0945_ VGND VGND VPWR VPWR _0948_ sky130_fd_sc_hd__o221a_2
XFILLER_10_69 VGND VGND VPWR VPWR sky130_fd_sc_hd__decap_3
XFILLER_59_257 VGND VGND VPWR VPWR sky130_fd_sc_hd__decap_3
XFILLER_35_22 VGND VGND VPWR VPWR sky130_fd_sc_hd__fill_1
XFILLER_27_121 VGND VGND VPWR VPWR sky130_fd_sc_hd__decap_3
XFILLER_15_327 VGND VGND VPWR VPWR sky130_fd_sc_hd__decap_3
XFILLER_51_43 VGND VGND VPWR VPWR sky130_fd_sc_hd__decap_3
XFILLER_51_21 VGND VGND VPWR VPWR sky130_fd_sc_hd__decap_3
XFILLER_42_168 VGND VGND VPWR VPWR sky130_fd_sc_hd__decap_3
XFILLER_42_157 VGND VGND VPWR VPWR sky130_fd_sc_hd__decap_3
XTAP_TAPCELL_ROW_25_300 VGND VPWR sky130_fd_sc_hd__tapvpwrvgnd_1
XFILLER_51_87 VGND VGND VPWR VPWR sky130_fd_sc_hd__decap_3
XPHY_EDGE_ROW_2_Left_65 VGND VGND VPWR VPWR sky130_fd_sc_hd__decap_3
XTAP_TAPCELL_ROW_48_447 VGND VPWR sky130_fd_sc_hd__tapvpwrvgnd_1
XFILLER_33_113 VGND VGND VPWR VPWR sky130_fd_sc_hd__fill_2
XFILLER_18_110 VGND VGND VPWR VPWR sky130_fd_sc_hd__decap_3
X_1882_ _1425_ _1422_ _1153_ VGND VGND VPWR VPWR _1426_ sky130_fd_sc_hd__or3b_1
XTAP_TAPCELL_ROW_31_336 VGND VPWR sky130_fd_sc_hd__tapvpwrvgnd_1
X_1951_ net100 net123 net97 net252 VGND VGND VPWR VPWR _0360_ sky130_fd_sc_hd__or4_1
XFILLER_14_360 VGND VGND VPWR VPWR sky130_fd_sc_hd__decap_3
X_2365_ my_sum_sub.state\[2\] net217 _0680_ VGND VGND VPWR VPWR _0308_ sky130_fd_sc_hd__o21a_1
X_2434_ _0727_ _0730_ VGND VGND VPWR VPWR _0733_ sky130_fd_sc_hd__nor2_1
X_2503_ _0793_ _0776_ _0766_ _0794_ VGND VGND VPWR VPWR _0802_ sky130_fd_sc_hd__or4_4
XFILLER_56_249 VGND VGND VPWR VPWR sky130_fd_sc_hd__decap_3
X_2296_ _0616_ _0618_ VGND VGND VPWR VPWR _0619_ sky130_fd_sc_hd__and2_1
XFILLER_62_219 VGND VGND VPWR VPWR sky130_fd_sc_hd__decap_3
XFILLER_46_54 VGND VGND VPWR VPWR sky130_fd_sc_hd__decap_3
XFILLER_46_43 VGND VGND VPWR VPWR sky130_fd_sc_hd__fill_2
XFILLER_46_21 VGND VGND VPWR VPWR sky130_fd_sc_hd__decap_3
XTAP_TAPCELL_ROW_45_428 VGND VPWR sky130_fd_sc_hd__tapvpwrvgnd_1
XFILLER_62_97 VGND VGND VPWR VPWR sky130_fd_sc_hd__decap_3
XFILLER_62_53 VGND VGND VPWR VPWR sky130_fd_sc_hd__decap_3
XFILLER_30_149 VGND VGND VPWR VPWR sky130_fd_sc_hd__fill_2
XFILLER_30_116 VGND VGND VPWR VPWR sky130_fd_sc_hd__decap_3
XFILLER_53_208 VGND VGND VPWR VPWR sky130_fd_sc_hd__decap_3
X_2081_ _0368_ _0379_ _0461_ _0478_ VGND VGND VPWR VPWR _0479_ sky130_fd_sc_hd__and4_1
XFILLER_38_249 VGND VGND VPWR VPWR sky130_fd_sc_hd__decap_3
XFILLER_38_216 VGND VGND VPWR VPWR sky130_fd_sc_hd__fill_1
X_2150_ net302 _0504_ _0506_ _0433_ VGND VGND VPWR VPWR _0349_ sky130_fd_sc_hd__o22a_1
XFILLER_61_296 VGND VGND VPWR VPWR sky130_fd_sc_hd__decap_3
XFILLER_61_274 VGND VGND VPWR VPWR sky130_fd_sc_hd__decap_3
XFILLER_61_241 VGND VGND VPWR VPWR sky130_fd_sc_hd__decap_3
X_1934_ _1423_ _1474_ _1476_ _1473_ VGND VGND VPWR VPWR _1478_ sky130_fd_sc_hd__a211o_1
X_2983_ net2 VGND VGND VPWR VPWR _0079_ sky130_fd_sc_hd__inv_2
X_1796_ _1334_ _1335_ _1336_ VGND VGND VPWR VPWR _1340_ sky130_fd_sc_hd__o21ai_1
X_1865_ _1316_ _1338_ VGND VGND VPWR VPWR _1409_ sky130_fd_sc_hd__xnor2_1
X_2348_ _0604_ _0659_ _0665_ _0616_ _1055_ VGND VGND VPWR VPWR _0666_ sky130_fd_sc_hd__a221o_1
X_2417_ _0698_ _0702_ VGND VGND VPWR VPWR _0716_ sky130_fd_sc_hd__and2_1
XFILLER_52_241 VGND VGND VPWR VPWR sky130_fd_sc_hd__decap_3
X_2279_ _0604_ VGND VGND VPWR VPWR _0605_ sky130_fd_sc_hd__inv_2
XTAP_TAPCELL_ROW_42_409 VGND VPWR sky130_fd_sc_hd__tapvpwrvgnd_1
XFILLER_32_23 VGND VGND VPWR VPWR sky130_fd_sc_hd__decap_3
XFILLER_20_171 VGND VGND VPWR VPWR sky130_fd_sc_hd__decap_3
XFILLER_4_304 VGND VGND VPWR VPWR sky130_fd_sc_hd__decap_3
XFILLER_57_97 VGND VGND VPWR VPWR sky130_fd_sc_hd__decap_3
XFILLER_57_75 VGND VGND VPWR VPWR sky130_fd_sc_hd__decap_3
XFILLER_57_53 VGND VGND VPWR VPWR sky130_fd_sc_hd__decap_3
XFILLER_43_230 VGND VGND VPWR VPWR sky130_fd_sc_hd__decap_3
XFILLER_28_293 VGND VGND VPWR VPWR sky130_fd_sc_hd__decap_3
X_1650_ my_mul.x2\[5\] acc_reg\[4\] _1192_ _1190_ VGND VGND VPWR VPWR _1194_ sky130_fd_sc_hd__a31o_1
X_1581_ acc_reg\[8\] my_mul.x2\[8\] VGND VGND VPWR VPWR _1125_ sky130_fd_sc_hd__nand2b_1
Xhold109 _0330_ VGND VGND VPWR VPWR net114 sky130_fd_sc_hd__dlygate4sd3_1
XFILLER_7_197 VGND VGND VPWR VPWR sky130_fd_sc_hd__decap_3
X_2202_ _1056_ my_sum_sub.al_ma\[0\] _0523_ VGND VGND VPWR VPWR _0537_ sky130_fd_sc_hd__or3b_1
XFILLER_19_260 VGND VGND VPWR VPWR sky130_fd_sc_hd__fill_1
X_2064_ net35 _1088_ _1090_ net157 VGND VGND VPWR VPWR _0465_ sky130_fd_sc_hd__a22o_1
X_2133_ net239 my_mul.x2\[6\] _0500_ VGND VGND VPWR VPWR _0197_ sky130_fd_sc_hd__mux2_1
X_1917_ _1458_ _1459_ VGND VGND VPWR VPWR _1461_ sky130_fd_sc_hd__or2_1
X_2897_ net5 VGND VGND VPWR VPWR _0178_ sky130_fd_sc_hd__inv_2
X_2966_ net2 VGND VGND VPWR VPWR _0062_ sky130_fd_sc_hd__inv_2
X_1779_ _1321_ _1322_ VGND VGND VPWR VPWR _1323_ sky130_fd_sc_hd__xnor2_1
X_1848_ _1383_ _1385_ VGND VGND VPWR VPWR _1392_ sky130_fd_sc_hd__nor2_1
XFILLER_8_80 VGND VGND VPWR VPWR sky130_fd_sc_hd__fill_1
XFILLER_57_355 VGND VGND VPWR VPWR sky130_fd_sc_hd__decap_3
XFILLER_57_311 VGND VGND VPWR VPWR sky130_fd_sc_hd__decap_3
XFILLER_27_23 VGND VGND VPWR VPWR sky130_fd_sc_hd__decap_3
XFILLER_40_200 VGND VGND VPWR VPWR sky130_fd_sc_hd__fill_2
XPHY_EDGE_ROW_31_Left_94 VGND VGND VPWR VPWR sky130_fd_sc_hd__decap_3
XFILLER_0_340 VGND VGND VPWR VPWR sky130_fd_sc_hd__decap_3
X_2751_ acc_reg\[4\] _0364_ _0973_ _1021_ VGND VGND VPWR VPWR _0264_ sky130_fd_sc_hd__a31o_1
X_2820_ net5 VGND VGND VPWR VPWR _0101_ sky130_fd_sc_hd__inv_2
X_1702_ my_mul.x2\[2\] acc_reg\[6\] VGND VGND VPWR VPWR _1246_ sky130_fd_sc_hd__nand2_1
X_1633_ _1172_ _1176_ VGND VGND VPWR VPWR _1177_ sky130_fd_sc_hd__xnor2_1
X_2682_ net274 _0742_ _0947_ VGND VGND VPWR VPWR _0968_ sky130_fd_sc_hd__and3_1
X_1564_ my_mul.x2\[12\] acc_reg\[12\] VGND VGND VPWR VPWR _1108_ sky130_fd_sc_hd__nand2_1
X_1495_ my_mul.x2\[14\] VGND VGND VPWR VPWR _1050_ sky130_fd_sc_hd__inv_2
X_3165_ clknet_4_0_0_clk sclk _0076_ VGND VGND VPWR VPWR sclk_s0 sky130_fd_sc_hd__dfrtp_1
XFILLER_54_336 VGND VGND VPWR VPWR sky130_fd_sc_hd__decap_3
X_3096_ clknet_4_7_0_clk net153 _0192_ VGND VGND VPWR VPWR my_mul.x2\[1\] sky130_fd_sc_hd__dfrtp_4
X_2047_ _1488_ _0368_ _0448_ _0449_ VGND VGND VPWR VPWR _0450_ sky130_fd_sc_hd__a31o_1
X_2116_ net235 net190 net88 VGND VGND VPWR VPWR _0211_ sky130_fd_sc_hd__mux2_1
X_2949_ net5 VGND VGND VPWR VPWR _0045_ sky130_fd_sc_hd__inv_2
XFILLER_49_119 VGND VGND VPWR VPWR sky130_fd_sc_hd__decap_3
XFILLER_57_196 VGND VGND VPWR VPWR sky130_fd_sc_hd__decap_3
XFILLER_57_141 VGND VGND VPWR VPWR sky130_fd_sc_hd__decap_3
XFILLER_54_21 VGND VGND VPWR VPWR sky130_fd_sc_hd__decap_3
XFILLER_45_347 VGND VGND VPWR VPWR sky130_fd_sc_hd__decap_3
XFILLER_60_339 VGND VGND VPWR VPWR sky130_fd_sc_hd__decap_3
XFILLER_55_9 VGND VGND VPWR VPWR sky130_fd_sc_hd__decap_3
XTAP_TAPCELL_ROW_23_283 VGND VPWR sky130_fd_sc_hd__tapvpwrvgnd_1
XFILLER_48_141 VGND VGND VPWR VPWR sky130_fd_sc_hd__decap_3
XFILLER_0_181 VGND VGND VPWR VPWR sky130_fd_sc_hd__decap_3
X_2734_ my_divider.remainder_reg\[6\] _1007_ _1002_ VGND VGND VPWR VPWR _1008_ sky130_fd_sc_hd__mux2_1
XFILLER_8_281 VGND VGND VPWR VPWR sky130_fd_sc_hd__decap_3
X_2803_ net182 _1040_ VGND VGND VPWR VPWR _0001_ sky130_fd_sc_hd__and2_1
X_1616_ _1157_ _1159_ VGND VGND VPWR VPWR _1160_ sky130_fd_sc_hd__nor2_1
X_2596_ _0800_ _0894_ VGND VGND VPWR VPWR _0895_ sky130_fd_sc_hd__nor2_1
X_1547_ state\[4\] net224 _1090_ VGND VGND VPWR VPWR _1092_ sky130_fd_sc_hd__and3_1
X_2665_ _1057_ net179 _0934_ _0958_ VGND VGND VPWR VPWR _0286_ sky130_fd_sc_hd__a22o_1
XFILLER_54_144 VGND VGND VPWR VPWR sky130_fd_sc_hd__decap_3
XFILLER_54_100 VGND VGND VPWR VPWR sky130_fd_sc_hd__decap_3
XFILLER_39_174 VGND VGND VPWR VPWR sky130_fd_sc_hd__decap_3
XFILLER_27_369 VGND VGND VPWR VPWR sky130_fd_sc_hd__fill_1
X_3148_ clknet_4_1_0_clk _0244_ _0059_ VGND VGND VPWR VPWR op_reg\[0\] sky130_fd_sc_hd__dfrtp_2
XFILLER_42_306 VGND VGND VPWR VPWR sky130_fd_sc_hd__fill_2
X_3079_ clknet_4_6_0_clk _0338_ _0175_ VGND VGND VPWR VPWR acc_reg\[0\] sky130_fd_sc_hd__dfrtp_4
XTAP_TAPCELL_ROW_37_375 VGND VPWR sky130_fd_sc_hd__tapvpwrvgnd_1
XFILLER_24_68 VGND VGND VPWR VPWR sky130_fd_sc_hd__fill_2
XFILLER_10_203 VGND VGND VPWR VPWR sky130_fd_sc_hd__fill_1
XTAP_TAPCELL_ROW_20_264 VGND VPWR sky130_fd_sc_hd__tapvpwrvgnd_1
XFILLER_10_247 VGND VGND VPWR VPWR sky130_fd_sc_hd__decap_3
Xhold270 _0324_ VGND VGND VPWR VPWR net275 sky130_fd_sc_hd__dlygate4sd3_1
XFILLER_49_54 VGND VGND VPWR VPWR sky130_fd_sc_hd__fill_2
XFILLER_49_32 VGND VGND VPWR VPWR sky130_fd_sc_hd__decap_3
Xhold281 _1009_ VGND VGND VPWR VPWR net286 sky130_fd_sc_hd__dlygate4sd3_1
Xhold292 my_divider.divisor_reg\[6\] VGND VGND VPWR VPWR net297 sky130_fd_sc_hd__dlygate4sd3_1
XFILLER_45_188 VGND VGND VPWR VPWR sky130_fd_sc_hd__decap_3
XFILLER_45_166 VGND VGND VPWR VPWR sky130_fd_sc_hd__fill_2
XFILLER_45_111 VGND VGND VPWR VPWR sky130_fd_sc_hd__fill_1
XTAP_TAPCELL_ROW_28_320 VGND VPWR sky130_fd_sc_hd__tapvpwrvgnd_1
XFILLER_18_325 VGND VGND VPWR VPWR sky130_fd_sc_hd__decap_3
XFILLER_18_336 VGND VGND VPWR VPWR sky130_fd_sc_hd__decap_3
XFILLER_41_350 VGND VGND VPWR VPWR sky130_fd_sc_hd__decap_3
XFILLER_53_6 VGND VGND VPWR VPWR sky130_fd_sc_hd__decap_3
X_2381_ _0606_ _0676_ VGND VGND VPWR VPWR _0689_ sky130_fd_sc_hd__and2_1
X_2450_ _0708_ _0734_ VGND VGND VPWR VPWR _0749_ sky130_fd_sc_hd__or2_1
XFILLER_5_240 VGND VGND VPWR VPWR sky130_fd_sc_hd__fill_2
XFILLER_5_262 VGND VGND VPWR VPWR sky130_fd_sc_hd__fill_1
XFILLER_36_144 VGND VGND VPWR VPWR sky130_fd_sc_hd__fill_2
X_3002_ clknet_4_8_0_clk net139 _0098_ VGND VGND VPWR VPWR my_divider.remainder_reg\[1\]
+ sky130_fd_sc_hd__dfrtp_1
XFILLER_51_169 VGND VGND VPWR VPWR sky130_fd_sc_hd__decap_3
XTAP_TAPCELL_ROW_34_356 VGND VPWR sky130_fd_sc_hd__tapvpwrvgnd_1
X_2717_ _0989_ _0992_ _0988_ VGND VGND VPWR VPWR _0993_ sky130_fd_sc_hd__o21a_1
XFILLER_10_15 VGND VGND VPWR VPWR sky130_fd_sc_hd__decap_3
XFILLER_59_269 VGND VGND VPWR VPWR sky130_fd_sc_hd__decap_3
XFILLER_59_236 VGND VGND VPWR VPWR sky130_fd_sc_hd__decap_3
XFILLER_59_225 VGND VGND VPWR VPWR sky130_fd_sc_hd__fill_2
X_2648_ net317 _0730_ _0823_ my_sum_sub.cm_mant\[1\] _0946_ VGND VGND VPWR VPWR _0947_
+ sky130_fd_sc_hd__o221a_1
X_2579_ _0877_ VGND VGND VPWR VPWR _0878_ sky130_fd_sc_hd__inv_2
XFILLER_27_199 VGND VGND VPWR VPWR sky130_fd_sc_hd__fill_1
XFILLER_27_144 VGND VGND VPWR VPWR sky130_fd_sc_hd__decap_3
XFILLER_27_133 VGND VGND VPWR VPWR sky130_fd_sc_hd__fill_1
XFILLER_27_111 VGND VGND VPWR VPWR sky130_fd_sc_hd__fill_1
XFILLER_15_306 VGND VGND VPWR VPWR sky130_fd_sc_hd__decap_3
XFILLER_51_66 VGND VGND VPWR VPWR sky130_fd_sc_hd__decap_3
XFILLER_51_55 VGND VGND VPWR VPWR sky130_fd_sc_hd__fill_1
XFILLER_51_33 VGND VGND VPWR VPWR sky130_fd_sc_hd__decap_3
XFILLER_50_191 VGND VGND VPWR VPWR sky130_fd_sc_hd__decap_3
XFILLER_42_147 VGND VGND VPWR VPWR sky130_fd_sc_hd__decap_3
XFILLER_23_350 VGND VGND VPWR VPWR sky130_fd_sc_hd__decap_3
XFILLER_58_280 VGND VGND VPWR VPWR sky130_fd_sc_hd__decap_3
XTAP_TAPCELL_ROW_48_448 VGND VPWR sky130_fd_sc_hd__tapvpwrvgnd_1
XFILLER_2_287 VGND VGND VPWR VPWR sky130_fd_sc_hd__decap_3
X_1950_ my_mul.x2\[3\] my_mul.x2\[2\] my_mul.x2\[1\] my_mul.x2\[0\] VGND VGND VPWR
+ VPWR _0359_ sky130_fd_sc_hd__or4_1
XFILLER_18_155 VGND VGND VPWR VPWR sky130_fd_sc_hd__decap_3
X_1881_ _1052_ _1424_ _1127_ VGND VGND VPWR VPWR _1425_ sky130_fd_sc_hd__a21o_1
XTAP_TAPCELL_ROW_31_337 VGND VPWR sky130_fd_sc_hd__tapvpwrvgnd_1
X_2502_ _0766_ _0794_ VGND VGND VPWR VPWR _0801_ sky130_fd_sc_hd__nor2_1
XFILLER_51_3 VGND VGND VPWR VPWR sky130_fd_sc_hd__fill_2
X_2364_ _0604_ _0675_ _0679_ _0616_ _1055_ VGND VGND VPWR VPWR _0680_ sky130_fd_sc_hd__a221o_1
X_2433_ _0712_ _0731_ VGND VGND VPWR VPWR _0732_ sky130_fd_sc_hd__nor2_1
X_2295_ _0617_ _0442_ _0604_ VGND VGND VPWR VPWR _0618_ sky130_fd_sc_hd__mux2_2
XFILLER_12_309 VGND VGND VPWR VPWR sky130_fd_sc_hd__fill_2
XFILLER_21_69 VGND VGND VPWR VPWR sky130_fd_sc_hd__fill_1
XFILLER_47_206 VGND VGND VPWR VPWR sky130_fd_sc_hd__decap_3
XFILLER_62_32 VGND VGND VPWR VPWR sky130_fd_sc_hd__decap_3
XFILLER_62_21 VGND VGND VPWR VPWR sky130_fd_sc_hd__decap_3
XFILLER_46_66 VGND VGND VPWR VPWR sky130_fd_sc_hd__decap_3
XTAP_TAPCELL_ROW_45_429 VGND VPWR sky130_fd_sc_hd__tapvpwrvgnd_1
XFILLER_30_128 VGND VGND VPWR VPWR sky130_fd_sc_hd__decap_3
XFILLER_15_158 VGND VGND VPWR VPWR sky130_fd_sc_hd__decap_3
XFILLER_15_169 VGND VGND VPWR VPWR sky130_fd_sc_hd__decap_3
XFILLER_7_324 VGND VGND VPWR VPWR sky130_fd_sc_hd__fill_1
XFILLER_7_368 VGND VGND VPWR VPWR sky130_fd_sc_hd__fill_2
XFILLER_11_331 VGND VGND VPWR VPWR sky130_fd_sc_hd__decap_3
Xclkbuf_4_9_0_clk clknet_0_clk VGND VGND VPWR VPWR clknet_4_9_0_clk sky130_fd_sc_hd__clkbuf_8
XFILLER_46_250 VGND VGND VPWR VPWR sky130_fd_sc_hd__fill_2
X_2080_ _1467_ _0460_ VGND VGND VPWR VPWR _0478_ sky130_fd_sc_hd__nand2_1
XFILLER_16_6 VGND VGND VPWR VPWR sky130_fd_sc_hd__decap_3
XFILLER_61_253 VGND VGND VPWR VPWR sky130_fd_sc_hd__decap_3
X_1933_ _1423_ _1473_ _1476_ VGND VGND VPWR VPWR _1477_ sky130_fd_sc_hd__a21o_1
X_2982_ net2 VGND VGND VPWR VPWR _0078_ sky130_fd_sc_hd__inv_2
X_1864_ _1360_ _1407_ _1358_ VGND VGND VPWR VPWR _1408_ sky130_fd_sc_hd__a21oi_1
X_1795_ _1316_ _1338_ VGND VGND VPWR VPWR _1339_ sky130_fd_sc_hd__and2_1
X_2347_ _0664_ VGND VGND VPWR VPWR _0665_ sky130_fd_sc_hd__inv_2
X_2278_ _1050_ acc_reg\[14\] _0603_ VGND VGND VPWR VPWR _0604_ sky130_fd_sc_hd__a21oi_4
X_2416_ _0713_ _0714_ VGND VGND VPWR VPWR _0715_ sky130_fd_sc_hd__nor2_1
XFILLER_52_253 VGND VGND VPWR VPWR sky130_fd_sc_hd__decap_3
XFILLER_52_220 VGND VGND VPWR VPWR sky130_fd_sc_hd__decap_3
XFILLER_44_209 VGND VGND VPWR VPWR sky130_fd_sc_hd__decap_3
XFILLER_4_349 VGND VGND VPWR VPWR sky130_fd_sc_hd__decap_3
XTAP_TAPCELL_ROW_58_510 VGND VPWR sky130_fd_sc_hd__tapvpwrvgnd_1
XFILLER_57_32 VGND VGND VPWR VPWR sky130_fd_sc_hd__decap_3
XFILLER_28_261 VGND VGND VPWR VPWR sky130_fd_sc_hd__fill_1
XFILLER_28_250 VGND VGND VPWR VPWR sky130_fd_sc_hd__fill_2
XPHY_EDGE_ROW_44_Left_107 VGND VGND VPWR VPWR sky130_fd_sc_hd__decap_3
X_1580_ my_mul.x2\[8\] acc_reg\[8\] VGND VGND VPWR VPWR _1124_ sky130_fd_sc_hd__and2b_1
XPHY_EDGE_ROW_53_Left_116 VGND VGND VPWR VPWR sky130_fd_sc_hd__decap_3
X_2201_ _0535_ VGND VGND VPWR VPWR _0536_ sky130_fd_sc_hd__inv_2
X_2132_ net92 net110 _0500_ VGND VGND VPWR VPWR _0198_ sky130_fd_sc_hd__mux2_1
X_2063_ _1482_ _0463_ _0458_ VGND VGND VPWR VPWR _0464_ sky130_fd_sc_hd__o21ba_1
XFILLER_34_253 VGND VGND VPWR VPWR sky130_fd_sc_hd__decap_3
XFILLER_19_294 VGND VGND VPWR VPWR sky130_fd_sc_hd__decap_3
XPHY_EDGE_ROW_62_Left_125 VGND VGND VPWR VPWR sky130_fd_sc_hd__decap_3
X_1847_ _1382_ _1387_ VGND VGND VPWR VPWR _1391_ sky130_fd_sc_hd__xnor2_1
X_1916_ _1183_ _1420_ _1457_ VGND VGND VPWR VPWR _1460_ sky130_fd_sc_hd__a21o_1
X_2896_ net5 VGND VGND VPWR VPWR _0177_ sky130_fd_sc_hd__inv_2
X_2965_ net2 VGND VGND VPWR VPWR _0061_ sky130_fd_sc_hd__inv_2
X_1778_ my_mul.x2\[2\] acc_reg\[3\] VGND VGND VPWR VPWR _1322_ sky130_fd_sc_hd__nand2_1
XFILLER_57_367 VGND VGND VPWR VPWR sky130_fd_sc_hd__decap_3
XFILLER_57_323 VGND VGND VPWR VPWR sky130_fd_sc_hd__decap_3
XFILLER_43_12 VGND VGND VPWR VPWR sky130_fd_sc_hd__decap_3
XFILLER_40_245 VGND VGND VPWR VPWR sky130_fd_sc_hd__decap_3
XFILLER_4_113 VGND VGND VPWR VPWR sky130_fd_sc_hd__decap_3
XFILLER_48_323 VGND VGND VPWR VPWR sky130_fd_sc_hd__fill_2
XFILLER_0_352 VGND VGND VPWR VPWR sky130_fd_sc_hd__decap_3
XFILLER_0_330 VGND VGND VPWR VPWR sky130_fd_sc_hd__decap_3
XFILLER_31_201 VGND VGND VPWR VPWR sky130_fd_sc_hd__decap_3
XFILLER_16_231 VGND VGND VPWR VPWR sky130_fd_sc_hd__decap_3
XFILLER_16_253 VGND VGND VPWR VPWR sky130_fd_sc_hd__fill_2
XFILLER_17_90 VGND VGND VPWR VPWR sky130_fd_sc_hd__fill_2
X_1701_ _1243_ _1244_ VGND VGND VPWR VPWR _1245_ sky130_fd_sc_hd__or2_1
XFILLER_31_223 VGND VGND VPWR VPWR sky130_fd_sc_hd__fill_1
X_2750_ net289 _0974_ _1020_ _0972_ VGND VGND VPWR VPWR _1021_ sky130_fd_sc_hd__a22o_1
X_2681_ _0958_ _0961_ _0967_ net37 _1057_ VGND VGND VPWR VPWR _0279_ sky130_fd_sc_hd__a32o_1
X_1632_ _1173_ _1175_ VGND VGND VPWR VPWR _1176_ sky130_fd_sc_hd__nor2_1
X_1563_ _1105_ _1106_ VGND VGND VPWR VPWR _1107_ sky130_fd_sc_hd__or2_2
X_1494_ net283 VGND VGND VPWR VPWR _1049_ sky130_fd_sc_hd__inv_2
XFILLER_54_326 VGND VGND VPWR VPWR sky130_fd_sc_hd__fill_2
XFILLER_39_345 VGND VGND VPWR VPWR sky130_fd_sc_hd__decap_3
XFILLER_39_334 VGND VGND VPWR VPWR sky130_fd_sc_hd__fill_2
X_3095_ clknet_4_5_0_clk _0354_ _0191_ VGND VGND VPWR VPWR my_mul.x2\[0\] sky130_fd_sc_hd__dfrtp_4
X_3164_ clknet_4_0_0_clk _0000_ _0075_ VGND VGND VPWR VPWR div_start sky130_fd_sc_hd__dfrtp_1
X_2115_ net239 net235 net88 VGND VGND VPWR VPWR _0212_ sky130_fd_sc_hd__mux2_1
X_2046_ _1088_ _0397_ _0407_ _1090_ VGND VGND VPWR VPWR _0449_ sky130_fd_sc_hd__a31o_1
X_2879_ net2 VGND VGND VPWR VPWR _0160_ sky130_fd_sc_hd__inv_2
X_2948_ net5 VGND VGND VPWR VPWR _0044_ sky130_fd_sc_hd__inv_2
XFILLER_13_37 VGND VGND VPWR VPWR sky130_fd_sc_hd__fill_2
XFILLER_49_109 VGND VGND VPWR VPWR sky130_fd_sc_hd__decap_3
XFILLER_1_105 VGND VGND VPWR VPWR sky130_fd_sc_hd__fill_1
XFILLER_1_127 VGND VGND VPWR VPWR sky130_fd_sc_hd__fill_2
XFILLER_60_318 VGND VGND VPWR VPWR sky130_fd_sc_hd__decap_3
XFILLER_60_307 VGND VGND VPWR VPWR sky130_fd_sc_hd__fill_1
XFILLER_54_66 VGND VGND VPWR VPWR sky130_fd_sc_hd__decap_3
XFILLER_38_56 VGND VGND VPWR VPWR sky130_fd_sc_hd__fill_2
XFILLER_54_88 VGND VGND VPWR VPWR sky130_fd_sc_hd__decap_3
XTAP_TAPCELL_ROW_23_284 VGND VPWR sky130_fd_sc_hd__tapvpwrvgnd_1
XFILLER_13_289 VGND VGND VPWR VPWR sky130_fd_sc_hd__decap_3
XFILLER_48_9 VGND VGND VPWR VPWR sky130_fd_sc_hd__decap_3
XFILLER_36_337 VGND VGND VPWR VPWR sky130_fd_sc_hd__decap_3
X_2733_ _0997_ _1006_ VGND VGND VPWR VPWR _1007_ sky130_fd_sc_hd__nor2_1
X_2802_ _1060_ net182 net232 VGND VGND VPWR VPWR _0000_ sky130_fd_sc_hd__and3_1
X_2664_ _1057_ net150 _0929_ _0958_ VGND VGND VPWR VPWR _0287_ sky130_fd_sc_hd__a22o_1
X_1615_ _1157_ _1158_ my_mul.x2\[5\] acc_reg\[6\] VGND VGND VPWR VPWR _1159_ sky130_fd_sc_hd__and4bb_1
X_2595_ _0742_ _0826_ _0893_ _0770_ _0891_ VGND VGND VPWR VPWR _0894_ sky130_fd_sc_hd__o221a_1
X_1546_ _1084_ _1089_ VGND VGND VPWR VPWR _1091_ sky130_fd_sc_hd__nand2_4
XFILLER_54_156 VGND VGND VPWR VPWR sky130_fd_sc_hd__fill_1
XFILLER_54_112 VGND VGND VPWR VPWR sky130_fd_sc_hd__decap_3
XFILLER_39_142 VGND VGND VPWR VPWR sky130_fd_sc_hd__fill_2
XFILLER_27_337 VGND VGND VPWR VPWR sky130_fd_sc_hd__decap_3
X_3147_ clknet_4_0_0_clk net147 _0058_ VGND VGND VPWR VPWR bit_count\[4\] sky130_fd_sc_hd__dfrtp_1
X_3078_ clknet_4_0_0_clk net205 _0174_ VGND VGND VPWR VPWR net4 sky130_fd_sc_hd__dfrtp_1
XFILLER_42_329 VGND VGND VPWR VPWR sky130_fd_sc_hd__decap_3
XTAP_TAPCELL_ROW_37_376 VGND VPWR sky130_fd_sc_hd__tapvpwrvgnd_1
X_2029_ net58 _1099_ _0433_ _0434_ VGND VGND VPWR VPWR _0234_ sky130_fd_sc_hd__o22a_1
Xhold260 _0323_ VGND VGND VPWR VPWR net265 sky130_fd_sc_hd__dlygate4sd3_1
Xhold271 my_sum_sub.cm_mant\[1\] VGND VGND VPWR VPWR net276 sky130_fd_sc_hd__dlygate4sd3_1
XTAP_TAPCELL_ROW_20_265 VGND VPWR sky130_fd_sc_hd__tapvpwrvgnd_1
Xhold282 _0267_ VGND VGND VPWR VPWR net287 sky130_fd_sc_hd__dlygate4sd3_1
Xhold293 _1039_ VGND VGND VPWR VPWR net298 sky130_fd_sc_hd__dlygate4sd3_1
XFILLER_60_159 VGND VGND VPWR VPWR sky130_fd_sc_hd__fill_1
XFILLER_60_137 VGND VGND VPWR VPWR sky130_fd_sc_hd__decap_3
XFILLER_45_145 VGND VGND VPWR VPWR sky130_fd_sc_hd__decap_3
XFILLER_18_348 VGND VGND VPWR VPWR sky130_fd_sc_hd__decap_3
XFILLER_46_6 VGND VGND VPWR VPWR sky130_fd_sc_hd__decap_3
X_2380_ _1055_ net216 _0673_ _0681_ _0688_ VGND VGND VPWR VPWR _0301_ sky130_fd_sc_hd__a221o_1
XFILLER_5_296 VGND VGND VPWR VPWR sky130_fd_sc_hd__fill_1
X_3001_ clknet_4_8_0_clk net215 _0097_ VGND VGND VPWR VPWR my_divider.remainder_reg\[0\]
+ sky130_fd_sc_hd__dfrtp_1
XFILLER_51_148 VGND VGND VPWR VPWR sky130_fd_sc_hd__decap_3
XFILLER_36_189 VGND VGND VPWR VPWR sky130_fd_sc_hd__decap_3
XTAP_TAPCELL_ROW_34_357 VGND VPWR sky130_fd_sc_hd__tapvpwrvgnd_1
X_2647_ my_sum_sub.cm_mant\[2\] net8 VGND VGND VPWR VPWR _0946_ sky130_fd_sc_hd__nand2b_1
X_2716_ _1058_ net229 _0991_ VGND VGND VPWR VPWR _0992_ sky130_fd_sc_hd__a21oi_1
XFILLER_10_49 VGND VGND VPWR VPWR sky130_fd_sc_hd__fill_2
XFILLER_59_248 VGND VGND VPWR VPWR sky130_fd_sc_hd__decap_3
XFILLER_59_215 VGND VGND VPWR VPWR sky130_fd_sc_hd__decap_3
XFILLER_19_47 VGND VGND VPWR VPWR sky130_fd_sc_hd__fill_1
X_1529_ net146 _1070_ _1073_ _1078_ VGND VGND VPWR VPWR _0243_ sky130_fd_sc_hd__a22o_1
X_2578_ _0845_ _0848_ _0866_ _0872_ _0836_ VGND VGND VPWR VPWR _0877_ sky130_fd_sc_hd__o311a_1
XFILLER_42_104 VGND VGND VPWR VPWR sky130_fd_sc_hd__decap_3
XFILLER_15_318 VGND VGND VPWR VPWR sky130_fd_sc_hd__decap_3
XFILLER_51_78 VGND VGND VPWR VPWR sky130_fd_sc_hd__fill_1
XFILLER_50_170 VGND VGND VPWR VPWR sky130_fd_sc_hd__decap_3
XFILLER_23_362 VGND VGND VPWR VPWR sky130_fd_sc_hd__decap_3
XPHY_EDGE_ROW_14_Right_14 VGND VGND VPWR VPWR sky130_fd_sc_hd__decap_3
XPHY_EDGE_ROW_23_Right_23 VGND VGND VPWR VPWR sky130_fd_sc_hd__decap_3
XFILLER_58_292 VGND VGND VPWR VPWR sky130_fd_sc_hd__decap_3
XTAP_TAPCELL_ROW_48_449 VGND VPWR sky130_fd_sc_hd__tapvpwrvgnd_1
XFILLER_41_192 VGND VGND VPWR VPWR sky130_fd_sc_hd__decap_3
XFILLER_41_181 VGND VGND VPWR VPWR sky130_fd_sc_hd__fill_2
X_1880_ acc_reg\[7\] _1126_ VGND VGND VPWR VPWR _1424_ sky130_fd_sc_hd__nor2_1
XPHY_EDGE_ROW_32_Right_32 VGND VGND VPWR VPWR sky130_fd_sc_hd__decap_3
XTAP_TAPCELL_ROW_31_338 VGND VPWR sky130_fd_sc_hd__tapvpwrvgnd_1
XFILLER_25_90 VGND VGND VPWR VPWR sky130_fd_sc_hd__decap_3
X_2501_ _0770_ _0798_ VGND VGND VPWR VPWR _0800_ sky130_fd_sc_hd__or2_2
XFILLER_44_3 VGND VGND VPWR VPWR sky130_fd_sc_hd__fill_2
X_2363_ _0648_ _0678_ _0618_ VGND VGND VPWR VPWR _0679_ sky130_fd_sc_hd__mux2_1
XPHY_EDGE_ROW_41_Right_41 VGND VGND VPWR VPWR sky130_fd_sc_hd__decap_3
X_2294_ _1130_ _0613_ VGND VGND VPWR VPWR _0617_ sky130_fd_sc_hd__xnor2_1
X_2432_ net26 _0730_ VGND VGND VPWR VPWR _0731_ sky130_fd_sc_hd__nor2_1
XPHY_EDGE_ROW_50_Right_50 VGND VGND VPWR VPWR sky130_fd_sc_hd__decap_3
XFILLER_49_270 VGND VGND VPWR VPWR sky130_fd_sc_hd__fill_2
XFILLER_2_83 VGND VGND VPWR VPWR sky130_fd_sc_hd__fill_1
XFILLER_20_343 VGND VGND VPWR VPWR sky130_fd_sc_hd__fill_1
XFILLER_55_240 VGND VGND VPWR VPWR sky130_fd_sc_hd__decap_3
XFILLER_46_12 VGND VGND VPWR VPWR sky130_fd_sc_hd__decap_3
XFILLER_62_88 VGND VGND VPWR VPWR sky130_fd_sc_hd__decap_3
XFILLER_62_77 VGND VGND VPWR VPWR sky130_fd_sc_hd__decap_3
XFILLER_62_66 VGND VGND VPWR VPWR sky130_fd_sc_hd__fill_2
XFILLER_62_44 VGND VGND VPWR VPWR sky130_fd_sc_hd__decap_3
XFILLER_55_295 VGND VGND VPWR VPWR sky130_fd_sc_hd__fill_1
XFILLER_46_78 VGND VGND VPWR VPWR sky130_fd_sc_hd__decap_3
XFILLER_23_192 VGND VGND VPWR VPWR sky130_fd_sc_hd__fill_2
XFILLER_11_343 VGND VGND VPWR VPWR sky130_fd_sc_hd__decap_3
XFILLER_38_207 VGND VGND VPWR VPWR sky130_fd_sc_hd__decap_3
XFILLER_38_229 VGND VGND VPWR VPWR sky130_fd_sc_hd__decap_3
XFILLER_61_287 VGND VGND VPWR VPWR sky130_fd_sc_hd__decap_3
XFILLER_61_265 VGND VGND VPWR VPWR sky130_fd_sc_hd__decap_3
X_1863_ _1377_ _1406_ _1376_ VGND VGND VPWR VPWR _1407_ sky130_fd_sc_hd__a21bo_1
X_1932_ _1183_ _1420_ _1464_ VGND VGND VPWR VPWR _1476_ sky130_fd_sc_hd__and3_1
X_2981_ net2 VGND VGND VPWR VPWR _0077_ sky130_fd_sc_hd__inv_2
XFILLER_14_192 VGND VGND VPWR VPWR sky130_fd_sc_hd__decap_3
X_1794_ _1334_ _1337_ VGND VGND VPWR VPWR _1338_ sky130_fd_sc_hd__nand2b_1
X_2415_ net13 _0699_ net18 VGND VGND VPWR VPWR _0714_ sky130_fd_sc_hd__a21oi_2
X_2346_ _0634_ _0663_ _0618_ VGND VGND VPWR VPWR _0664_ sky130_fd_sc_hd__mux2_1
X_2277_ _1105_ _0602_ _1147_ VGND VGND VPWR VPWR _0603_ sky130_fd_sc_hd__o21a_1
XFILLER_52_276 VGND VGND VPWR VPWR sky130_fd_sc_hd__fill_1
XFILLER_52_232 VGND VGND VPWR VPWR sky130_fd_sc_hd__fill_2
XFILLER_12_118 VGND VGND VPWR VPWR sky130_fd_sc_hd__fill_1
XTAP_TAPCELL_ROW_58_511 VGND VPWR sky130_fd_sc_hd__tapvpwrvgnd_1
XFILLER_57_88 VGND VGND VPWR VPWR sky130_fd_sc_hd__decap_3
XFILLER_57_66 VGND VGND VPWR VPWR sky130_fd_sc_hd__decap_3
XFILLER_43_210 VGND VGND VPWR VPWR sky130_fd_sc_hd__decap_3
XFILLER_43_287 VGND VGND VPWR VPWR sky130_fd_sc_hd__decap_3
XFILLER_43_254 VGND VGND VPWR VPWR sky130_fd_sc_hd__decap_3
XTAP_TAPCELL_ROW_41_400 VGND VPWR sky130_fd_sc_hd__tapvpwrvgnd_1
XFILLER_7_111 VGND VGND VPWR VPWR sky130_fd_sc_hd__fill_1
X_2062_ _1478_ _0461_ VGND VGND VPWR VPWR _0463_ sky130_fd_sc_hd__nor2_1
X_2200_ _0520_ _0521_ VGND VGND VPWR VPWR _0535_ sky130_fd_sc_hd__or2_1
X_2131_ net68 my_mul.x2\[8\] _0500_ VGND VGND VPWR VPWR _0199_ sky130_fd_sc_hd__mux2_1
XFILLER_34_265 VGND VGND VPWR VPWR sky130_fd_sc_hd__fill_1
XFILLER_34_232 VGND VGND VPWR VPWR sky130_fd_sc_hd__fill_2
X_2964_ net2 VGND VGND VPWR VPWR _0060_ sky130_fd_sc_hd__inv_2
X_1777_ _1319_ _1320_ VGND VGND VPWR VPWR _1321_ sky130_fd_sc_hd__nor2_1
X_1846_ _1379_ _1388_ VGND VGND VPWR VPWR _1390_ sky130_fd_sc_hd__xnor2_1
X_1915_ _1183_ _1420_ _1457_ VGND VGND VPWR VPWR _1459_ sky130_fd_sc_hd__a21oi_1
X_2895_ net5 VGND VGND VPWR VPWR _0176_ sky130_fd_sc_hd__inv_2
XFILLER_57_302 VGND VGND VPWR VPWR sky130_fd_sc_hd__decap_3
XPHY_EDGE_ROW_4_Right_4 VGND VGND VPWR VPWR sky130_fd_sc_hd__decap_3
XFILLER_57_346 VGND VGND VPWR VPWR sky130_fd_sc_hd__decap_3
XFILLER_57_335 VGND VGND VPWR VPWR sky130_fd_sc_hd__fill_1
X_2329_ _0604_ _0643_ _0648_ _0619_ _1055_ VGND VGND VPWR VPWR _0649_ sky130_fd_sc_hd__a221o_1
XTAP_TAPCELL_ROW_4_158 VGND VPWR sky130_fd_sc_hd__tapvpwrvgnd_1
XFILLER_43_24 VGND VGND VPWR VPWR sky130_fd_sc_hd__decap_3
Xclkbuf_4_8_0_clk clknet_0_clk VGND VGND VPWR VPWR clknet_4_8_0_clk sky130_fd_sc_hd__clkbuf_8
XFILLER_4_136 VGND VGND VPWR VPWR sky130_fd_sc_hd__decap_3
XFILLER_48_368 VGND VGND VPWR VPWR sky130_fd_sc_hd__fill_2
XFILLER_48_346 VGND VGND VPWR VPWR sky130_fd_sc_hd__decap_3
XFILLER_16_298 VGND VGND VPWR VPWR sky130_fd_sc_hd__decap_3
XTAP_TAPCELL_ROW_18_249 VGND VPWR sky130_fd_sc_hd__tapvpwrvgnd_1
X_1631_ _1173_ _1174_ my_mul.x2\[5\] acc_reg\[5\] VGND VGND VPWR VPWR _1175_ sky130_fd_sc_hd__and4bb_1
X_1700_ my_mul.x2\[4\] my_mul.x2\[3\] acc_reg\[5\] acc_reg\[4\] VGND VGND VPWR VPWR
+ _1244_ sky130_fd_sc_hd__and4_1
XFILLER_31_268 VGND VGND VPWR VPWR sky130_fd_sc_hd__fill_1
X_2680_ _0799_ _0949_ VGND VGND VPWR VPWR _0967_ sky130_fd_sc_hd__nor2_1
X_1562_ acc_reg\[13\] my_mul.x2\[13\] VGND VGND VPWR VPWR _1106_ sky130_fd_sc_hd__and2b_1
X_2045_ _1426_ _0447_ _0372_ VGND VGND VPWR VPWR _0448_ sky130_fd_sc_hd__a21o_1
X_3094_ clknet_4_1_0_clk net248 _0190_ VGND VGND VPWR VPWR acc_reg\[15\] sky130_fd_sc_hd__dfrtp_2
XTAP_TAPCELL_ROW_1_139 VGND VPWR sky130_fd_sc_hd__tapvpwrvgnd_1
X_3163_ clknet_4_1_0_clk net183 _0074_ VGND VGND VPWR VPWR my_mul.reg1en.d\[0\] sky130_fd_sc_hd__dfrtp_1
X_2114_ net92 net239 net88 VGND VGND VPWR VPWR _0213_ sky130_fd_sc_hd__mux2_1
X_2947_ net5 VGND VGND VPWR VPWR _0043_ sky130_fd_sc_hd__inv_2
X_1829_ my_mul.x2\[0\] acc_reg\[4\] _1367_ _1366_ VGND VGND VPWR VPWR _1373_ sky130_fd_sc_hd__a31o_1
X_2878_ net2 VGND VGND VPWR VPWR _0159_ sky130_fd_sc_hd__inv_2
XFILLER_57_132 VGND VGND VPWR VPWR sky130_fd_sc_hd__fill_1
XFILLER_8_9 VGND VGND VPWR VPWR sky130_fd_sc_hd__fill_2
XFILLER_54_78 VGND VGND VPWR VPWR sky130_fd_sc_hd__decap_3
XFILLER_54_45 VGND VGND VPWR VPWR sky130_fd_sc_hd__fill_2
XFILLER_54_34 VGND VGND VPWR VPWR sky130_fd_sc_hd__fill_1
XFILLER_54_12 VGND VGND VPWR VPWR sky130_fd_sc_hd__decap_3
XTAP_TAPCELL_ROW_23_285 VGND VPWR sky130_fd_sc_hd__tapvpwrvgnd_1
XFILLER_0_172 VGND VGND VPWR VPWR sky130_fd_sc_hd__decap_3
X_2801_ net159 _1061_ net133 VGND VGND VPWR VPWR _0006_ sky130_fd_sc_hd__a21o_1
X_1614_ my_mul.x2\[6\] acc_reg\[5\] acc_reg\[4\] VGND VGND VPWR VPWR _1158_ sky130_fd_sc_hd__a21oi_1
X_2594_ my_sum_sub.cm_mant\[1\] _0730_ _0823_ my_sum_sub.cm_mant\[2\] _0892_ VGND
+ VGND VPWR VPWR _0893_ sky130_fd_sc_hd__o221a_1
X_2663_ _1057_ net161 _0912_ _0958_ VGND VGND VPWR VPWR _0288_ sky130_fd_sc_hd__a22o_1
X_2732_ _0976_ _0977_ _0996_ VGND VGND VPWR VPWR _1006_ sky130_fd_sc_hd__nor3_1
XFILLER_8_272 VGND VGND VPWR VPWR sky130_fd_sc_hd__decap_3
XFILLER_12_290 VGND VGND VPWR VPWR sky130_fd_sc_hd__decap_3
X_1545_ _1084_ _1089_ VGND VGND VPWR VPWR _1090_ sky130_fd_sc_hd__and2_4
XFILLER_39_198 VGND VGND VPWR VPWR sky130_fd_sc_hd__decap_3
XTAP_TAPCELL_ROW_37_377 VGND VPWR sky130_fd_sc_hd__tapvpwrvgnd_1
XFILLER_27_349 VGND VGND VPWR VPWR sky130_fd_sc_hd__decap_3
XFILLER_27_316 VGND VGND VPWR VPWR sky130_fd_sc_hd__fill_1
X_2028_ shift_out\[12\] _1064_ _1097_ acc_reg\[11\] _1100_ VGND VGND VPWR VPWR _0434_
+ sky130_fd_sc_hd__a221o_1
X_3077_ clknet_4_11_0_clk _0336_ _0173_ VGND VGND VPWR VPWR my_sum_sub.cm_exp\[7\]
+ sky130_fd_sc_hd__dfrtp_1
X_3146_ clknet_4_0_0_clk _0242_ _0057_ VGND VGND VPWR VPWR bit_count\[3\] sky130_fd_sc_hd__dfrtp_1
XFILLER_50_363 VGND VGND VPWR VPWR sky130_fd_sc_hd__fill_1
XFILLER_24_26 VGND VGND VPWR VPWR sky130_fd_sc_hd__fill_2
XFILLER_49_23 VGND VGND VPWR VPWR sky130_fd_sc_hd__decap_3
Xhold272 _0320_ VGND VGND VPWR VPWR net277 sky130_fd_sc_hd__dlygate4sd3_1
Xhold250 my_mul.x2\[5\] VGND VGND VPWR VPWR net255 sky130_fd_sc_hd__dlygate4sd3_1
Xhold261 acc_reg\[10\] VGND VGND VPWR VPWR net266 sky130_fd_sc_hd__dlygate4sd3_1
XTAP_TAPCELL_ROW_20_266 VGND VPWR sky130_fd_sc_hd__tapvpwrvgnd_1
Xhold283 my_divider.remainder_reg\[2\] VGND VGND VPWR VPWR net288 sky130_fd_sc_hd__dlygate4sd3_1
Xhold294 _0254_ VGND VGND VPWR VPWR net299 sky130_fd_sc_hd__dlygate4sd3_1
XFILLER_49_89 VGND VGND VPWR VPWR sky130_fd_sc_hd__decap_3
XFILLER_45_124 VGND VGND VPWR VPWR sky130_fd_sc_hd__decap_3
XFILLER_45_157 VGND VGND VPWR VPWR sky130_fd_sc_hd__decap_3
XFILLER_33_319 VGND VGND VPWR VPWR sky130_fd_sc_hd__fill_2
XFILLER_60_9 VGND VGND VPWR VPWR sky130_fd_sc_hd__decap_3
XFILLER_39_6 VGND VGND VPWR VPWR sky130_fd_sc_hd__decap_3
XFILLER_51_116 VGND VGND VPWR VPWR sky130_fd_sc_hd__decap_3
X_3000_ clknet_4_0_0_clk net145 _0096_ VGND VGND VPWR VPWR my_divider.counter\[3\]
+ sky130_fd_sc_hd__dfrtp_1
XTAP_TAPCELL_ROW_34_358 VGND VPWR sky130_fd_sc_hd__tapvpwrvgnd_1
XFILLER_32_363 VGND VGND VPWR VPWR sky130_fd_sc_hd__fill_1
X_2646_ _0893_ _0743_ my_sum_sub.cm_mant\[5\] VGND VGND VPWR VPWR _0945_ sky130_fd_sc_hd__or3b_1
X_2715_ _0989_ _0990_ VGND VGND VPWR VPWR _0991_ sky130_fd_sc_hd__or2_1
X_2577_ _0874_ _0875_ VGND VGND VPWR VPWR _0876_ sky130_fd_sc_hd__nor2_1
XFILLER_27_124 VGND VGND VPWR VPWR sky130_fd_sc_hd__fill_1
X_1528_ state\[5\] _1077_ _1075_ net146 VGND VGND VPWR VPWR _1078_ sky130_fd_sc_hd__a2bb2o_1
X_3129_ clknet_4_6_0_clk net47 _0040_ VGND VGND VPWR VPWR shift_out\[2\] sky130_fd_sc_hd__dfrtp_1
XFILLER_51_57 VGND VGND VPWR VPWR sky130_fd_sc_hd__decap_3
XFILLER_51_46 VGND VGND VPWR VPWR sky130_fd_sc_hd__decap_3
XFILLER_51_24 VGND VGND VPWR VPWR sky130_fd_sc_hd__decap_3
XFILLER_50_182 VGND VGND VPWR VPWR sky130_fd_sc_hd__decap_3
XFILLER_4_3 VGND VGND VPWR VPWR sky130_fd_sc_hd__decap_3
XFILLER_2_267 VGND VGND VPWR VPWR sky130_fd_sc_hd__fill_1
XFILLER_58_271 VGND VGND VPWR VPWR sky130_fd_sc_hd__decap_3
XFILLER_18_113 VGND VGND VPWR VPWR sky130_fd_sc_hd__decap_3
XTAP_TAPCELL_ROW_31_339 VGND VPWR sky130_fd_sc_hd__tapvpwrvgnd_1
XFILLER_26_190 VGND VGND VPWR VPWR sky130_fd_sc_hd__decap_3
XFILLER_14_363 VGND VGND VPWR VPWR sky130_fd_sc_hd__fill_1
X_2431_ net20 my_sum_sub.cm_mant\[7\] VGND VGND VPWR VPWR _0730_ sky130_fd_sc_hd__or2_2
X_2500_ _0770_ _0798_ VGND VGND VPWR VPWR _0799_ sky130_fd_sc_hd__nor2_2
X_2362_ _0628_ _0662_ _0671_ _0677_ VGND VGND VPWR VPWR _0678_ sky130_fd_sc_hd__a2bb2o_1
XFILLER_37_3 VGND VGND VPWR VPWR sky130_fd_sc_hd__decap_3
X_2293_ _0611_ _0612_ _0615_ VGND VGND VPWR VPWR _0616_ sky130_fd_sc_hd__and3_1
XFILLER_24_138 VGND VGND VPWR VPWR sky130_fd_sc_hd__fill_2
XFILLER_20_333 VGND VGND VPWR VPWR sky130_fd_sc_hd__fill_2
X_2629_ net19 _0908_ _0927_ _0906_ VGND VGND VPWR VPWR _0928_ sky130_fd_sc_hd__o22ai_2
XFILLER_55_252 VGND VGND VPWR VPWR sky130_fd_sc_hd__decap_3
XFILLER_46_57 VGND VGND VPWR VPWR sky130_fd_sc_hd__decap_3
XFILLER_46_24 VGND VGND VPWR VPWR sky130_fd_sc_hd__decap_3
XPHY_EDGE_ROW_6_Left_69 VGND VGND VPWR VPWR sky130_fd_sc_hd__decap_3
XFILLER_62_12 VGND VGND VPWR VPWR sky130_fd_sc_hd__decap_3
XFILLER_30_119 VGND VGND VPWR VPWR sky130_fd_sc_hd__decap_3
XFILLER_11_311 VGND VGND VPWR VPWR sky130_fd_sc_hd__fill_2
XFILLER_11_322 VGND VGND VPWR VPWR sky130_fd_sc_hd__decap_3
XFILLER_7_337 VGND VGND VPWR VPWR sky130_fd_sc_hd__decap_3
XFILLER_7_359 VGND VGND VPWR VPWR sky130_fd_sc_hd__decap_3
XFILLER_61_277 VGND VGND VPWR VPWR sky130_fd_sc_hd__decap_3
XFILLER_61_244 VGND VGND VPWR VPWR sky130_fd_sc_hd__decap_3
XFILLER_61_222 VGND VGND VPWR VPWR sky130_fd_sc_hd__fill_2
XFILLER_46_274 VGND VGND VPWR VPWR sky130_fd_sc_hd__decap_3
XFILLER_46_263 VGND VGND VPWR VPWR sky130_fd_sc_hd__decap_3
XFILLER_46_241 VGND VGND VPWR VPWR sky130_fd_sc_hd__decap_3
XTAP_TAPCELL_ROW_44_420 VGND VPWR sky130_fd_sc_hd__tapvpwrvgnd_1
X_2980_ net2 VGND VGND VPWR VPWR _0076_ sky130_fd_sc_hd__inv_2
XFILLER_61_299 VGND VGND VPWR VPWR sky130_fd_sc_hd__decap_3
X_1793_ _1334_ _1335_ _1336_ VGND VGND VPWR VPWR _1337_ sky130_fd_sc_hd__or3_1
X_1862_ _1390_ _1405_ _1389_ VGND VGND VPWR VPWR _1406_ sky130_fd_sc_hd__o21ai_1
X_1931_ _1473_ _1474_ _1423_ VGND VGND VPWR VPWR _1475_ sky130_fd_sc_hd__mux2_1
X_2414_ net18 net13 _0699_ VGND VGND VPWR VPWR _0713_ sky130_fd_sc_hd__and3_1
XFILLER_52_200 VGND VGND VPWR VPWR sky130_fd_sc_hd__decap_3
X_2345_ _0647_ _0662_ _0628_ VGND VGND VPWR VPWR _0663_ sky130_fd_sc_hd__mux2_1
XFILLER_37_252 VGND VGND VPWR VPWR sky130_fd_sc_hd__decap_3
XFILLER_29_219 VGND VGND VPWR VPWR sky130_fd_sc_hd__decap_3
X_2276_ _0601_ VGND VGND VPWR VPWR _0602_ sky130_fd_sc_hd__inv_2
XFILLER_52_266 VGND VGND VPWR VPWR sky130_fd_sc_hd__fill_2
XFILLER_52_244 VGND VGND VPWR VPWR sky130_fd_sc_hd__decap_3
XFILLER_52_211 VGND VGND VPWR VPWR sky130_fd_sc_hd__decap_3
XFILLER_32_26 VGND VGND VPWR VPWR sky130_fd_sc_hd__fill_2
XFILLER_20_174 VGND VGND VPWR VPWR sky130_fd_sc_hd__decap_3
XFILLER_4_307 VGND VGND VPWR VPWR sky130_fd_sc_hd__fill_1
XTAP_TAPCELL_ROW_58_512 VGND VPWR sky130_fd_sc_hd__tapvpwrvgnd_1
XFILLER_57_12 VGND VGND VPWR VPWR sky130_fd_sc_hd__fill_2
XTAP_TAPCELL_ROW_7_178 VGND VPWR sky130_fd_sc_hd__tapvpwrvgnd_1
XFILLER_43_233 VGND VGND VPWR VPWR sky130_fd_sc_hd__decap_3
XFILLER_43_222 VGND VGND VPWR VPWR sky130_fd_sc_hd__fill_2
XFILLER_28_296 VGND VGND VPWR VPWR sky130_fd_sc_hd__fill_2
XFILLER_28_241 VGND VGND VPWR VPWR sky130_fd_sc_hd__fill_1
XFILLER_28_230 VGND VGND VPWR VPWR sky130_fd_sc_hd__decap_3
XTAP_TAPCELL_ROW_41_401 VGND VPWR sky130_fd_sc_hd__tapvpwrvgnd_1
XFILLER_11_152 VGND VGND VPWR VPWR sky130_fd_sc_hd__fill_1
X_2061_ _1477_ _0461_ VGND VGND VPWR VPWR _0462_ sky130_fd_sc_hd__or2_1
XFILLER_34_200 VGND VGND VPWR VPWR sky130_fd_sc_hd__fill_1
X_2130_ net81 my_mul.x2\[9\] _0500_ VGND VGND VPWR VPWR _0200_ sky130_fd_sc_hd__mux2_1
X_1914_ _1183_ _1420_ _1449_ VGND VGND VPWR VPWR _1458_ sky130_fd_sc_hd__and3_1
X_2963_ net2 VGND VGND VPWR VPWR _0059_ sky130_fd_sc_hd__inv_2
X_1776_ my_mul.x2\[4\] my_mul.x2\[3\] acc_reg\[2\] acc_reg\[1\] VGND VGND VPWR VPWR
+ _1320_ sky130_fd_sc_hd__and4_1
X_1845_ _1379_ _1388_ VGND VGND VPWR VPWR _1389_ sky130_fd_sc_hd__or2_1
X_2894_ net5 VGND VGND VPWR VPWR _0175_ sky130_fd_sc_hd__inv_2
XFILLER_8_72 VGND VGND VPWR VPWR sky130_fd_sc_hd__fill_2
X_2328_ _0633_ _0646_ _0628_ VGND VGND VPWR VPWR _0648_ sky130_fd_sc_hd__mux2_1
XFILLER_57_358 VGND VGND VPWR VPWR sky130_fd_sc_hd__decap_3
X_2259_ net268 _0588_ net127 VGND VGND VPWR VPWR _0322_ sky130_fd_sc_hd__mux2_1
XFILLER_27_26 VGND VGND VPWR VPWR sky130_fd_sc_hd__fill_1
XFILLER_25_222 VGND VGND VPWR VPWR sky130_fd_sc_hd__fill_2
XTAP_TAPCELL_ROW_4_159 VGND VPWR sky130_fd_sc_hd__tapvpwrvgnd_1
XFILLER_0_321 VGND VGND VPWR VPWR sky130_fd_sc_hd__decap_3
XFILLER_0_365 VGND VGND VPWR VPWR sky130_fd_sc_hd__decap_3
XFILLER_0_343 VGND VGND VPWR VPWR sky130_fd_sc_hd__decap_3
XTAP_TAPCELL_ROW_61_529 VGND VPWR sky130_fd_sc_hd__tapvpwrvgnd_1
XFILLER_31_236 VGND VGND VPWR VPWR sky130_fd_sc_hd__decap_3
XPHY_EDGE_ROW_9_Left_72 VGND VGND VPWR VPWR sky130_fd_sc_hd__decap_3
X_1630_ my_mul.x2\[6\] acc_reg\[4\] acc_reg\[3\] VGND VGND VPWR VPWR _1174_ sky130_fd_sc_hd__a21oi_1
X_1561_ my_mul.x2\[13\] acc_reg\[13\] VGND VGND VPWR VPWR _1105_ sky130_fd_sc_hd__and2b_1
XFILLER_3_192 VGND VGND VPWR VPWR sky130_fd_sc_hd__fill_1
X_3162_ clknet_4_2_0_clk _0002_ _0073_ VGND VGND VPWR VPWR my_sum_sub.start sky130_fd_sc_hd__dfrtp_1
XFILLER_54_339 VGND VGND VPWR VPWR sky130_fd_sc_hd__fill_2
X_2044_ _1153_ _1423_ _1425_ VGND VGND VPWR VPWR _0447_ sky130_fd_sc_hd__a21bo_1
X_2113_ net68 net92 net88 VGND VGND VPWR VPWR _0214_ sky130_fd_sc_hd__mux2_1
X_3093_ clknet_4_3_0_clk net296 _0189_ VGND VGND VPWR VPWR acc_reg\[14\] sky130_fd_sc_hd__dfrtp_4
XFILLER_62_361 VGND VGND VPWR VPWR sky130_fd_sc_hd__decap_3
X_2946_ net5 VGND VGND VPWR VPWR _0042_ sky130_fd_sc_hd__inv_2
X_2877_ net2 VGND VGND VPWR VPWR _0158_ sky130_fd_sc_hd__inv_2
XFILLER_13_28 VGND VGND VPWR VPWR sky130_fd_sc_hd__decap_3
X_1828_ _1362_ _1371_ VGND VGND VPWR VPWR _1372_ sky130_fd_sc_hd__nor2_1
X_1759_ my_mul.x2\[0\] _1302_ VGND VGND VPWR VPWR _1303_ sky130_fd_sc_hd__nor2_1
XFILLER_57_144 VGND VGND VPWR VPWR sky130_fd_sc_hd__decap_3
XFILLER_57_100 VGND VGND VPWR VPWR sky130_fd_sc_hd__decap_3
XFILLER_60_309 VGND VGND VPWR VPWR sky130_fd_sc_hd__decap_3
XFILLER_57_199 VGND VGND VPWR VPWR sky130_fd_sc_hd__fill_1
XFILLER_54_57 VGND VGND VPWR VPWR sky130_fd_sc_hd__decap_3
XFILLER_54_24 VGND VGND VPWR VPWR sky130_fd_sc_hd__decap_3
XFILLER_13_225 VGND VGND VPWR VPWR sky130_fd_sc_hd__decap_3
XPHY_EDGE_ROW_35_Left_98 VGND VGND VPWR VPWR sky130_fd_sc_hd__decap_3
XTAP_TAPCELL_ROW_23_286 VGND VPWR sky130_fd_sc_hd__tapvpwrvgnd_1
XFILLER_9_229 VGND VGND VPWR VPWR sky130_fd_sc_hd__fill_2
XFILLER_48_188 VGND VGND VPWR VPWR sky130_fd_sc_hd__fill_2
XFILLER_48_144 VGND VGND VPWR VPWR sky130_fd_sc_hd__fill_1
XFILLER_0_184 VGND VGND VPWR VPWR sky130_fd_sc_hd__decap_3
X_2731_ _0972_ _1004_ _1005_ _0974_ net245 VGND VGND VPWR VPWR _0268_ sky130_fd_sc_hd__a32o_1
X_2800_ net254 _1045_ net281 net202 VGND VGND VPWR VPWR _0007_ sky130_fd_sc_hd__a211o_1
X_1613_ my_mul.x2\[6\] acc_reg\[5\] acc_reg\[4\] VGND VGND VPWR VPWR _1157_ sky130_fd_sc_hd__and3_1
X_2593_ my_sum_sub.cm_mant\[3\] net8 VGND VGND VPWR VPWR _0892_ sky130_fd_sc_hd__nand2b_1
X_2662_ _1057_ net191 _0936_ _0958_ VGND VGND VPWR VPWR _0289_ sky130_fd_sc_hd__a22o_1
X_1544_ my_sum_sub.operation op_reg\[2\] op_reg\[0\] op_reg\[1\] VGND VGND VPWR VPWR
+ _1089_ sky130_fd_sc_hd__or4b_2
XFILLER_8_284 VGND VGND VPWR VPWR sky130_fd_sc_hd__fill_2
XFILLER_39_177 VGND VGND VPWR VPWR sky130_fd_sc_hd__decap_3
Xclkbuf_4_7_0_clk clknet_0_clk VGND VGND VPWR VPWR clknet_4_7_0_clk sky130_fd_sc_hd__clkbuf_8
X_3145_ clknet_4_0_0_clk _0241_ _0056_ VGND VGND VPWR VPWR bit_count\[2\] sky130_fd_sc_hd__dfrtp_1
XFILLER_62_180 VGND VGND VPWR VPWR sky130_fd_sc_hd__decap_3
XPHY_EDGE_ROW_59_Left_122 VGND VGND VPWR VPWR sky130_fd_sc_hd__decap_3
XFILLER_54_147 VGND VGND VPWR VPWR sky130_fd_sc_hd__decap_3
XFILLER_54_103 VGND VGND VPWR VPWR sky130_fd_sc_hd__fill_1
XFILLER_50_320 VGND VGND VPWR VPWR sky130_fd_sc_hd__decap_3
XTAP_TAPCELL_ROW_37_378 VGND VPWR sky130_fd_sc_hd__tapvpwrvgnd_1
XFILLER_35_350 VGND VGND VPWR VPWR sky130_fd_sc_hd__decap_3
X_2027_ net150 _1091_ _0432_ net280 VGND VGND VPWR VPWR _0433_ sky130_fd_sc_hd__o211a_1
X_3076_ clknet_4_11_0_clk net120 _0172_ VGND VGND VPWR VPWR my_sum_sub.cm_exp\[6\]
+ sky130_fd_sc_hd__dfrtp_2
XFILLER_40_26 VGND VGND VPWR VPWR sky130_fd_sc_hd__fill_2
X_2929_ net2 VGND VGND VPWR VPWR _0025_ sky130_fd_sc_hd__inv_2
XTAP_TAPCELL_ROW_20_267 VGND VPWR sky130_fd_sc_hd__tapvpwrvgnd_1
XFILLER_49_57 VGND VGND VPWR VPWR sky130_fd_sc_hd__decap_3
XFILLER_49_35 VGND VGND VPWR VPWR sky130_fd_sc_hd__decap_3
Xhold251 my_sum_sub.cm_mant\[2\] VGND VGND VPWR VPWR net256 sky130_fd_sc_hd__dlygate4sd3_1
Xhold262 _0348_ VGND VGND VPWR VPWR net267 sky130_fd_sc_hd__dlygate4sd3_1
Xhold240 my_divider.remainder_reg\[8\] VGND VGND VPWR VPWR net245 sky130_fd_sc_hd__dlygate4sd3_1
Xhold273 bit_count\[0\] VGND VGND VPWR VPWR net278 sky130_fd_sc_hd__dlygate4sd3_1
Xhold284 my_divider.remainder_reg\[4\] VGND VGND VPWR VPWR net289 sky130_fd_sc_hd__dlygate4sd3_1
Xhold295 my_divider.remainder_reg\[6\] VGND VGND VPWR VPWR net300 sky130_fd_sc_hd__dlygate4sd3_1
XFILLER_45_169 VGND VGND VPWR VPWR sky130_fd_sc_hd__decap_3
XFILLER_18_328 VGND VGND VPWR VPWR sky130_fd_sc_hd__fill_2
XFILLER_18_339 VGND VGND VPWR VPWR sky130_fd_sc_hd__decap_3
XFILLER_41_353 VGND VGND VPWR VPWR sky130_fd_sc_hd__decap_3
XFILLER_41_320 VGND VGND VPWR VPWR sky130_fd_sc_hd__decap_3
XFILLER_26_350 VGND VGND VPWR VPWR sky130_fd_sc_hd__decap_3
XFILLER_53_9 VGND VGND VPWR VPWR sky130_fd_sc_hd__decap_3
XFILLER_5_287 VGND VGND VPWR VPWR sky130_fd_sc_hd__fill_2
XFILLER_44_180 VGND VGND VPWR VPWR sky130_fd_sc_hd__decap_3
XFILLER_36_136 VGND VGND VPWR VPWR sky130_fd_sc_hd__decap_3
XTAP_TAPCELL_ROW_34_359 VGND VPWR sky130_fd_sc_hd__tapvpwrvgnd_1
X_2714_ my_divider.remainder_reg\[1\] net79 VGND VGND VPWR VPWR _0990_ sky130_fd_sc_hd__and2b_1
X_1527_ _1067_ _1076_ VGND VGND VPWR VPWR _1077_ sky130_fd_sc_hd__nand2_1
XFILLER_10_18 VGND VGND VPWR VPWR sky130_fd_sc_hd__fill_2
X_2576_ _0846_ _0849_ _0867_ VGND VGND VPWR VPWR _0875_ sky130_fd_sc_hd__and3_1
X_2645_ _0925_ _0928_ _0933_ _0941_ VGND VGND VPWR VPWR _0944_ sky130_fd_sc_hd__and4_1
X_3128_ clknet_4_6_0_clk net50 _0039_ VGND VGND VPWR VPWR shift_out\[1\] sky130_fd_sc_hd__dfrtp_1
XFILLER_27_147 VGND VGND VPWR VPWR sky130_fd_sc_hd__decap_3
XFILLER_51_36 VGND VGND VPWR VPWR sky130_fd_sc_hd__fill_1
XFILLER_50_194 VGND VGND VPWR VPWR sky130_fd_sc_hd__fill_2
XFILLER_50_161 VGND VGND VPWR VPWR sky130_fd_sc_hd__decap_3
XFILLER_42_139 VGND VGND VPWR VPWR sky130_fd_sc_hd__fill_1
X_3059_ clknet_4_12_0_clk _0318_ _0155_ VGND VGND VPWR VPWR my_sum_sub.al_b_larger
+ sky130_fd_sc_hd__dfrtp_4
XFILLER_27_169 VGND VGND VPWR VPWR sky130_fd_sc_hd__decap_3
XFILLER_15_309 VGND VGND VPWR VPWR sky130_fd_sc_hd__decap_3
XFILLER_51_69 VGND VGND VPWR VPWR sky130_fd_sc_hd__decap_3
XFILLER_58_250 VGND VGND VPWR VPWR sky130_fd_sc_hd__fill_2
XFILLER_58_283 VGND VGND VPWR VPWR sky130_fd_sc_hd__decap_3
XFILLER_14_331 VGND VGND VPWR VPWR sky130_fd_sc_hd__decap_3
XFILLER_18_158 VGND VGND VPWR VPWR sky130_fd_sc_hd__decap_3
XFILLER_25_70 VGND VGND VPWR VPWR sky130_fd_sc_hd__decap_3
X_2361_ _0668_ _0675_ _0667_ _0676_ _1153_ _0604_ VGND VGND VPWR VPWR _0677_ sky130_fd_sc_hd__mux4_1
X_2430_ net8 my_sum_sub.cm_mant\[7\] VGND VGND VPWR VPWR _0729_ sky130_fd_sc_hd__nor2_1
XTAP_TAPCELL_ROW_47_440 VGND VPWR sky130_fd_sc_hd__tapvpwrvgnd_1
X_2292_ _1119_ _0614_ VGND VGND VPWR VPWR _0615_ sky130_fd_sc_hd__xnor2_1
XPHY_EDGE_ROW_22_Left_85 VGND VGND VPWR VPWR sky130_fd_sc_hd__decap_3
XFILLER_1_290 VGND VGND VPWR VPWR sky130_fd_sc_hd__decap_3
XFILLER_47_209 VGND VGND VPWR VPWR sky130_fd_sc_hd__decap_3
X_2559_ _0857_ VGND VGND VPWR VPWR _0858_ sky130_fd_sc_hd__inv_2
X_2628_ _0871_ _0905_ _0909_ VGND VGND VPWR VPWR _0927_ sky130_fd_sc_hd__o21ai_1
XFILLER_55_264 VGND VGND VPWR VPWR sky130_fd_sc_hd__fill_2
XFILLER_55_231 VGND VGND VPWR VPWR sky130_fd_sc_hd__decap_3
XFILLER_46_69 VGND VGND VPWR VPWR sky130_fd_sc_hd__decap_3
XFILLER_62_57 VGND VGND VPWR VPWR sky130_fd_sc_hd__decap_3
XFILLER_62_35 VGND VGND VPWR VPWR sky130_fd_sc_hd__decap_3
XFILLER_62_24 VGND VGND VPWR VPWR sky130_fd_sc_hd__decap_3
XFILLER_11_334 VGND VGND VPWR VPWR sky130_fd_sc_hd__fill_2
XFILLER_11_367 VGND VGND VPWR VPWR sky130_fd_sc_hd__decap_3
XFILLER_11_50 VGND VGND VPWR VPWR sky130_fd_sc_hd__fill_1
XFILLER_16_9 VGND VGND VPWR VPWR sky130_fd_sc_hd__decap_3
XFILLER_61_256 VGND VGND VPWR VPWR sky130_fd_sc_hd__decap_3
XFILLER_61_201 VGND VGND VPWR VPWR sky130_fd_sc_hd__decap_3
X_1930_ _1416_ _1419_ VGND VGND VPWR VPWR _1474_ sky130_fd_sc_hd__xnor2_1
XTAP_TAPCELL_ROW_44_421 VGND VPWR sky130_fd_sc_hd__tapvpwrvgnd_1
X_1792_ my_mul.x2\[0\] acc_reg\[6\] _1331_ _1330_ VGND VGND VPWR VPWR _1336_ sky130_fd_sc_hd__a31oi_1
XFILLER_52_90 VGND VGND VPWR VPWR sky130_fd_sc_hd__decap_3
X_1861_ _1399_ _1402_ _1403_ _1398_ VGND VGND VPWR VPWR _1405_ sky130_fd_sc_hd__o31a_1
X_2344_ _0622_ _0661_ VGND VGND VPWR VPWR _0662_ sky130_fd_sc_hd__nand2_1
X_2413_ _0710_ _0711_ VGND VGND VPWR VPWR _0712_ sky130_fd_sc_hd__nand2_1
XFILLER_52_223 VGND VGND VPWR VPWR sky130_fd_sc_hd__decap_3
XFILLER_37_231 VGND VGND VPWR VPWR sky130_fd_sc_hd__fill_2
X_2275_ _1107_ _0401_ VGND VGND VPWR VPWR _0601_ sky130_fd_sc_hd__nand2b_1
XFILLER_52_256 VGND VGND VPWR VPWR sky130_fd_sc_hd__fill_2
XTAP_TAPCELL_ROW_50_457 VGND VPWR sky130_fd_sc_hd__tapvpwrvgnd_1
XFILLER_32_38 VGND VGND VPWR VPWR sky130_fd_sc_hd__fill_2
XFILLER_12_109 VGND VGND VPWR VPWR sky130_fd_sc_hd__fill_1
XFILLER_20_197 VGND VGND VPWR VPWR sky130_fd_sc_hd__fill_1
XTAP_TAPCELL_ROW_58_513 VGND VPWR sky130_fd_sc_hd__tapvpwrvgnd_1
XFILLER_57_57 VGND VGND VPWR VPWR sky130_fd_sc_hd__decap_3
XFILLER_57_35 VGND VGND VPWR VPWR sky130_fd_sc_hd__fill_2
XTAP_TAPCELL_ROW_7_179 VGND VPWR sky130_fd_sc_hd__tapvpwrvgnd_1
XFILLER_43_201 VGND VGND VPWR VPWR sky130_fd_sc_hd__decap_3
XTAP_TAPCELL_ROW_41_402 VGND VPWR sky130_fd_sc_hd__tapvpwrvgnd_1
XFILLER_22_82 VGND VGND VPWR VPWR sky130_fd_sc_hd__fill_2
XFILLER_7_102 VGND VGND VPWR VPWR sky130_fd_sc_hd__decap_3
X_2060_ _1467_ _0460_ VGND VGND VPWR VPWR _0461_ sky130_fd_sc_hd__or2_1
XFILLER_19_297 VGND VGND VPWR VPWR sky130_fd_sc_hd__fill_1
X_1913_ _1408_ _1409_ VGND VGND VPWR VPWR _1457_ sky130_fd_sc_hd__xor2_1
XFILLER_34_256 VGND VGND VPWR VPWR sky130_fd_sc_hd__decap_3
X_2962_ net2 VGND VGND VPWR VPWR _0058_ sky130_fd_sc_hd__inv_2
X_2893_ net5 VGND VGND VPWR VPWR _0174_ sky130_fd_sc_hd__inv_2
X_1775_ my_mul.x2\[3\] acc_reg\[2\] acc_reg\[1\] my_mul.x2\[4\] VGND VGND VPWR VPWR
+ _1319_ sky130_fd_sc_hd__a22oi_1
X_1844_ _1382_ _1386_ _1380_ VGND VGND VPWR VPWR _1388_ sky130_fd_sc_hd__o21bai_1
XFILLER_57_337 VGND VGND VPWR VPWR sky130_fd_sc_hd__decap_3
XFILLER_57_326 VGND VGND VPWR VPWR sky130_fd_sc_hd__decap_3
X_2327_ _0646_ VGND VGND VPWR VPWR _0647_ sky130_fd_sc_hd__inv_2
X_2258_ _0551_ _0587_ VGND VGND VPWR VPWR _0588_ sky130_fd_sc_hd__xnor2_1
XPHY_EDGE_ROW_40_Left_103 VGND VGND VPWR VPWR sky130_fd_sc_hd__decap_3
X_2189_ _0522_ _0523_ VGND VGND VPWR VPWR _0524_ sky130_fd_sc_hd__nand2_1
XFILLER_40_248 VGND VGND VPWR VPWR sky130_fd_sc_hd__decap_3
XFILLER_4_116 VGND VGND VPWR VPWR sky130_fd_sc_hd__decap_3
XFILLER_0_355 VGND VGND VPWR VPWR sky130_fd_sc_hd__decap_3
XFILLER_0_333 VGND VGND VPWR VPWR sky130_fd_sc_hd__decap_3
XFILLER_31_204 VGND VGND VPWR VPWR sky130_fd_sc_hd__fill_1
XFILLER_16_278 VGND VGND VPWR VPWR sky130_fd_sc_hd__decap_3
X_1560_ net40 _1099_ _1104_ VGND VGND VPWR VPWR _0238_ sky130_fd_sc_hd__o21a_1
XFILLER_39_348 VGND VGND VPWR VPWR sky130_fd_sc_hd__fill_2
XFILLER_39_337 VGND VGND VPWR VPWR sky130_fd_sc_hd__fill_1
X_2112_ net81 net68 net88 VGND VGND VPWR VPWR _0215_ sky130_fd_sc_hd__mux2_1
X_3161_ clknet_4_14_0_clk net127 _0072_ VGND VGND VPWR VPWR my_sum_sub.state\[3\]
+ sky130_fd_sc_hd__dfrtp_4
XFILLER_62_340 VGND VGND VPWR VPWR sky130_fd_sc_hd__decap_3
XFILLER_54_307 VGND VGND VPWR VPWR sky130_fd_sc_hd__fill_1
X_2043_ net66 _1099_ _0445_ _0446_ VGND VGND VPWR VPWR _0232_ sky130_fd_sc_hd__o22a_1
XFILLER_22_204 VGND VGND VPWR VPWR sky130_fd_sc_hd__decap_3
X_3092_ clknet_4_3_0_clk net259 _0188_ VGND VGND VPWR VPWR acc_reg\[13\] sky130_fd_sc_hd__dfrtp_2
X_1827_ _1369_ _1370_ VGND VGND VPWR VPWR _1371_ sky130_fd_sc_hd__nand2_1
X_2945_ net5 VGND VGND VPWR VPWR _0041_ sky130_fd_sc_hd__inv_2
X_2876_ net2 VGND VGND VPWR VPWR _0157_ sky130_fd_sc_hd__inv_2
X_1689_ _1219_ _1220_ VGND VGND VPWR VPWR _1233_ sky130_fd_sc_hd__xor2_1
X_1758_ _1300_ _1301_ VGND VGND VPWR VPWR _1302_ sky130_fd_sc_hd__xnor2_1
XFILLER_57_167 VGND VGND VPWR VPWR sky130_fd_sc_hd__fill_1
XFILLER_45_329 VGND VGND VPWR VPWR sky130_fd_sc_hd__fill_1
XFILLER_54_69 VGND VGND VPWR VPWR sky130_fd_sc_hd__fill_1
XFILLER_53_340 VGND VGND VPWR VPWR sky130_fd_sc_hd__decap_3
XTAP_TAPCELL_ROW_0_130 VGND VPWR sky130_fd_sc_hd__tapvpwrvgnd_1
XTAP_TAPCELL_ROW_23_287 VGND VPWR sky130_fd_sc_hd__tapvpwrvgnd_1
XFILLER_0_141 VGND VGND VPWR VPWR sky130_fd_sc_hd__decap_3
XFILLER_44_340 VGND VGND VPWR VPWR sky130_fd_sc_hd__decap_3
X_2730_ my_divider.remainder_reg\[7\] _1002_ VGND VGND VPWR VPWR _1005_ sky130_fd_sc_hd__or2_1
XFILLER_12_281 VGND VGND VPWR VPWR sky130_fd_sc_hd__decap_3
X_2661_ _1057_ net125 _0922_ _0958_ VGND VGND VPWR VPWR _0290_ sky130_fd_sc_hd__a22o_1
XFILLER_60_90 VGND VGND VPWR VPWR sky130_fd_sc_hd__fill_1
X_1612_ my_mul.x2\[6\] acc_reg\[6\] _1155_ VGND VGND VPWR VPWR _1156_ sky130_fd_sc_hd__a21o_1
X_2592_ _0852_ _0743_ my_sum_sub.cm_mant\[5\] VGND VGND VPWR VPWR _0891_ sky130_fd_sc_hd__or3b_1
X_1543_ my_sum_sub.operation op_reg\[2\] net231 net223 VGND VGND VPWR VPWR _1088_
+ sky130_fd_sc_hd__nor4b_4
XFILLER_54_126 VGND VGND VPWR VPWR sky130_fd_sc_hd__fill_1
XFILLER_54_115 VGND VGND VPWR VPWR sky130_fd_sc_hd__decap_3
XFILLER_27_329 VGND VGND VPWR VPWR sky130_fd_sc_hd__decap_3
X_3075_ clknet_4_11_0_clk net118 _0171_ VGND VGND VPWR VPWR my_sum_sub.cm_exp\[5\]
+ sky130_fd_sc_hd__dfrtp_1
X_3144_ clknet_4_0_0_clk net189 _0055_ VGND VGND VPWR VPWR bit_count\[1\] sky130_fd_sc_hd__dfrtp_1
XFILLER_62_192 VGND VGND VPWR VPWR sky130_fd_sc_hd__decap_3
XFILLER_50_365 VGND VGND VPWR VPWR sky130_fd_sc_hd__decap_3
X_2026_ _1489_ _0368_ _0428_ _0431_ VGND VGND VPWR VPWR _0432_ sky130_fd_sc_hd__a31o_1
X_2859_ net2 VGND VGND VPWR VPWR _0140_ sky130_fd_sc_hd__inv_2
X_2928_ net2 VGND VGND VPWR VPWR _0024_ sky130_fd_sc_hd__inv_2
XTAP_TAPCELL_ROW_20_268 VGND VPWR sky130_fd_sc_hd__tapvpwrvgnd_1
Xhold252 my_sum_sub.al_ma\[6\] VGND VGND VPWR VPWR net257 sky130_fd_sc_hd__dlygate4sd3_1
Xhold263 my_sum_sub.cm_mant\[3\] VGND VGND VPWR VPWR net268 sky130_fd_sc_hd__dlygate4sd3_1
Xhold274 my_sum_sub.operation VGND VGND VPWR VPWR net279 sky130_fd_sc_hd__dlygate4sd3_1
Xhold241 _0268_ VGND VGND VPWR VPWR net246 sky130_fd_sc_hd__dlygate4sd3_1
Xhold285 _0264_ VGND VGND VPWR VPWR net290 sky130_fd_sc_hd__dlygate4sd3_1
Xhold296 _0266_ VGND VGND VPWR VPWR net301 sky130_fd_sc_hd__dlygate4sd3_1
Xhold230 shift_in\[5\] VGND VGND VPWR VPWR net235 sky130_fd_sc_hd__dlygate4sd3_1
XFILLER_60_118 VGND VGND VPWR VPWR sky130_fd_sc_hd__decap_3
XFILLER_45_148 VGND VGND VPWR VPWR sky130_fd_sc_hd__decap_3
XFILLER_26_362 VGND VGND VPWR VPWR sky130_fd_sc_hd__fill_2
XFILLER_46_9 VGND VGND VPWR VPWR sky130_fd_sc_hd__decap_3
XFILLER_44_192 VGND VGND VPWR VPWR sky130_fd_sc_hd__decap_3
XFILLER_17_351 VGND VGND VPWR VPWR sky130_fd_sc_hd__fill_2
X_2713_ my_divider.divisor_reg\[1\] net138 VGND VGND VPWR VPWR _0989_ sky130_fd_sc_hd__and2b_1
X_2644_ _0912_ _0917_ _0921_ _0937_ VGND VGND VPWR VPWR _0943_ sky130_fd_sc_hd__and4b_1
XFILLER_59_218 VGND VGND VPWR VPWR sky130_fd_sc_hd__decap_3
X_1526_ net146 _1075_ VGND VGND VPWR VPWR _1076_ sky130_fd_sc_hd__nor2_1
X_2575_ _0846_ _0867_ _0873_ VGND VGND VPWR VPWR _0874_ sky130_fd_sc_hd__a21oi_1
X_3127_ clknet_4_6_0_clk net222 _0038_ VGND VGND VPWR VPWR shift_out\[0\] sky130_fd_sc_hd__dfrtp_1
X_3058_ clknet_4_12_0_clk _0317_ _0154_ VGND VGND VPWR VPWR my_sum_sub.al_sb_eff sky130_fd_sc_hd__dfrtp_4
XFILLER_51_15 VGND VGND VPWR VPWR sky130_fd_sc_hd__fill_2
XFILLER_50_173 VGND VGND VPWR VPWR sky130_fd_sc_hd__decap_3
XFILLER_50_151 VGND VGND VPWR VPWR sky130_fd_sc_hd__decap_3
XFILLER_35_181 VGND VGND VPWR VPWR sky130_fd_sc_hd__decap_3
XFILLER_23_365 VGND VGND VPWR VPWR sky130_fd_sc_hd__decap_3
X_2009_ _1088_ _0407_ _0416_ _1090_ VGND VGND VPWR VPWR _0417_ sky130_fd_sc_hd__a31o_1
XFILLER_58_262 VGND VGND VPWR VPWR sky130_fd_sc_hd__decap_3
XFILLER_18_104 VGND VGND VPWR VPWR sky130_fd_sc_hd__decap_3
XFILLER_58_295 VGND VGND VPWR VPWR sky130_fd_sc_hd__decap_3
XTAP_TAPCELL_ROW_56_496 VGND VPWR sky130_fd_sc_hd__tapvpwrvgnd_1
XFILLER_14_365 VGND VGND VPWR VPWR sky130_fd_sc_hd__decap_3
Xclkbuf_4_6_0_clk clknet_0_clk VGND VGND VPWR VPWR clknet_4_6_0_clk sky130_fd_sc_hd__clkbuf_8
XFILLER_25_93 VGND VGND VPWR VPWR sky130_fd_sc_hd__fill_2
X_2360_ acc_reg\[0\] _0364_ VGND VGND VPWR VPWR _0676_ sky130_fd_sc_hd__and2_1
X_2291_ _1130_ _0613_ _1129_ VGND VGND VPWR VPWR _0614_ sky130_fd_sc_hd__a21oi_1
XFILLER_49_262 VGND VGND VPWR VPWR sky130_fd_sc_hd__decap_3
XTAP_TAPCELL_ROW_47_441 VGND VPWR sky130_fd_sc_hd__tapvpwrvgnd_1
XPHY_EDGE_ROW_10_Right_10 VGND VGND VPWR VPWR sky130_fd_sc_hd__decap_3
XFILLER_32_195 VGND VGND VPWR VPWR sky130_fd_sc_hd__fill_1
XTAP_TAPCELL_ROW_30_330 VGND VPWR sky130_fd_sc_hd__tapvpwrvgnd_1
XFILLER_17_192 VGND VGND VPWR VPWR sky130_fd_sc_hd__fill_1
X_2627_ _0925_ VGND VGND VPWR VPWR _0926_ sky130_fd_sc_hd__inv_2
XFILLER_46_15 VGND VGND VPWR VPWR sky130_fd_sc_hd__fill_1
X_1509_ net279 net92 _1062_ VGND VGND VPWR VPWR _0247_ sky130_fd_sc_hd__mux2_1
X_2558_ _0805_ _0816_ _0806_ VGND VGND VPWR VPWR _0857_ sky130_fd_sc_hd__a21bo_1
X_2489_ _0761_ _0787_ VGND VGND VPWR VPWR _0788_ sky130_fd_sc_hd__and2b_1
XFILLER_55_243 VGND VGND VPWR VPWR sky130_fd_sc_hd__decap_3
XFILLER_55_221 VGND VGND VPWR VPWR sky130_fd_sc_hd__decap_3
XFILLER_46_48 VGND VGND VPWR VPWR sky130_fd_sc_hd__decap_3
XFILLER_46_37 VGND VGND VPWR VPWR sky130_fd_sc_hd__decap_3
XFILLER_62_47 VGND VGND VPWR VPWR sky130_fd_sc_hd__decap_3
XTAP_TAPCELL_ROW_53_477 VGND VPWR sky130_fd_sc_hd__tapvpwrvgnd_1
XFILLER_11_302 VGND VGND VPWR VPWR sky130_fd_sc_hd__decap_3
XFILLER_11_346 VGND VGND VPWR VPWR sky130_fd_sc_hd__decap_3
XFILLER_61_268 VGND VGND VPWR VPWR sky130_fd_sc_hd__decap_3
XFILLER_61_235 VGND VGND VPWR VPWR sky130_fd_sc_hd__decap_3
X_1860_ _1399_ _1402_ _1403_ VGND VGND VPWR VPWR _1404_ sky130_fd_sc_hd__or3_1
XTAP_TAPCELL_ROW_44_422 VGND VPWR sky130_fd_sc_hd__tapvpwrvgnd_1
XFILLER_14_195 VGND VGND VPWR VPWR sky130_fd_sc_hd__fill_1
X_1791_ _1317_ _1325_ _1333_ VGND VGND VPWR VPWR _1335_ sky130_fd_sc_hd__nor3_1
X_2343_ _0652_ _0660_ _1153_ VGND VGND VPWR VPWR _0661_ sky130_fd_sc_hd__mux2_1
X_2274_ net127 _0594_ _0600_ VGND VGND VPWR VPWR _0319_ sky130_fd_sc_hd__a21oi_1
X_2412_ _1053_ _0697_ VGND VGND VPWR VPWR _0711_ sky130_fd_sc_hd__nand2_1
XFILLER_37_243 VGND VGND VPWR VPWR sky130_fd_sc_hd__decap_3
XFILLER_37_221 VGND VGND VPWR VPWR sky130_fd_sc_hd__decap_3
XTAP_TAPCELL_ROW_50_458 VGND VPWR sky130_fd_sc_hd__tapvpwrvgnd_1
X_1989_ _1119_ _1126_ _1131_ _1153_ VGND VGND VPWR VPWR _0398_ sky130_fd_sc_hd__or4b_1
XTAP_TAPCELL_ROW_58_514 VGND VPWR sky130_fd_sc_hd__tapvpwrvgnd_1
XFILLER_57_69 VGND VGND VPWR VPWR sky130_fd_sc_hd__decap_3
XFILLER_28_221 VGND VGND VPWR VPWR sky130_fd_sc_hd__decap_3
XFILLER_43_257 VGND VGND VPWR VPWR sky130_fd_sc_hd__decap_3
XFILLER_43_213 VGND VGND VPWR VPWR sky130_fd_sc_hd__decap_3
XTAP_TAPCELL_ROW_41_403 VGND VPWR sky130_fd_sc_hd__tapvpwrvgnd_1
XFILLER_22_50 VGND VGND VPWR VPWR sky130_fd_sc_hd__decap_3
XFILLER_3_320 VGND VGND VPWR VPWR sky130_fd_sc_hd__decap_3
XFILLER_7_147 VGND VGND VPWR VPWR sky130_fd_sc_hd__fill_1
XFILLER_47_91 VGND VGND VPWR VPWR sky130_fd_sc_hd__decap_3
XFILLER_34_246 VGND VGND VPWR VPWR sky130_fd_sc_hd__decap_3
XFILLER_19_221 VGND VGND VPWR VPWR sky130_fd_sc_hd__decap_3
X_1843_ _1380_ _1386_ VGND VGND VPWR VPWR _1387_ sky130_fd_sc_hd__xnor2_1
X_1912_ _1451_ _1455_ VGND VGND VPWR VPWR _1456_ sky130_fd_sc_hd__nand2_1
X_2892_ net2 VGND VGND VPWR VPWR _0173_ sky130_fd_sc_hd__inv_2
X_2961_ net2 VGND VGND VPWR VPWR _0057_ sky130_fd_sc_hd__inv_2
XFILLER_8_85 VGND VGND VPWR VPWR sky130_fd_sc_hd__fill_1
X_1774_ _1294_ _1296_ VGND VGND VPWR VPWR _1318_ sky130_fd_sc_hd__xor2_1
XFILLER_57_349 VGND VGND VPWR VPWR sky130_fd_sc_hd__decap_3
XFILLER_57_305 VGND VGND VPWR VPWR sky130_fd_sc_hd__decap_3
X_2326_ _0638_ _0645_ _1153_ VGND VGND VPWR VPWR _0646_ sky130_fd_sc_hd__mux2_1
X_2257_ _0556_ _0586_ _0546_ VGND VGND VPWR VPWR _0587_ sky130_fd_sc_hd__mux2_1
XFILLER_43_27 VGND VGND VPWR VPWR sky130_fd_sc_hd__fill_1
X_2188_ my_sum_sub.al_mb\[1\] my_sum_sub.al_ma\[1\] VGND VGND VPWR VPWR _0523_ sky130_fd_sc_hd__nand2b_1
XFILLER_25_279 VGND VGND VPWR VPWR sky130_fd_sc_hd__fill_1
XFILLER_25_202 VGND VGND VPWR VPWR sky130_fd_sc_hd__fill_2
XFILLER_4_139 VGND VGND VPWR VPWR sky130_fd_sc_hd__fill_1
XFILLER_0_312 VGND VGND VPWR VPWR sky130_fd_sc_hd__decap_3
XFILLER_48_349 VGND VGND VPWR VPWR sky130_fd_sc_hd__decap_3
X_2042_ net56 _1064_ _1097_ acc_reg\[9\] _1100_ VGND VGND VPWR VPWR _0446_ sky130_fd_sc_hd__a221o_1
X_2111_ net83 net81 _0498_ VGND VGND VPWR VPWR _0216_ sky130_fd_sc_hd__mux2_1
X_3091_ clknet_4_9_0_clk net272 _0187_ VGND VGND VPWR VPWR acc_reg\[12\] sky130_fd_sc_hd__dfrtp_2
X_3160_ clknet_4_3_0_clk _0003_ _0071_ VGND VGND VPWR VPWR my_sum_sub.state\[2\] sky130_fd_sc_hd__dfrtp_4
XFILLER_62_352 VGND VGND VPWR VPWR sky130_fd_sc_hd__decap_3
XFILLER_62_330 VGND VGND VPWR VPWR sky130_fd_sc_hd__decap_3
XPHY_EDGE_ROW_8_Right_8 VGND VGND VPWR VPWR sky130_fd_sc_hd__decap_3
X_1826_ _1343_ _1345_ VGND VGND VPWR VPWR _1370_ sky130_fd_sc_hd__xnor2_1
X_2944_ net5 VGND VGND VPWR VPWR _0040_ sky130_fd_sc_hd__inv_2
X_2875_ net2 VGND VGND VPWR VPWR _0156_ sky130_fd_sc_hd__inv_2
X_1757_ my_mul.x2\[1\] acc_reg\[6\] VGND VGND VPWR VPWR _1301_ sky130_fd_sc_hd__nand2_1
X_1688_ _1223_ _1224_ VGND VGND VPWR VPWR _1232_ sky130_fd_sc_hd__xnor2_1
XPHY_EDGE_ROW_39_Right_39 VGND VGND VPWR VPWR sky130_fd_sc_hd__decap_3
XFILLER_38_27 VGND VGND VPWR VPWR sky130_fd_sc_hd__fill_1
XFILLER_57_179 VGND VGND VPWR VPWR sky130_fd_sc_hd__decap_3
XFILLER_57_113 VGND VGND VPWR VPWR sky130_fd_sc_hd__decap_3
XFILLER_54_15 VGND VGND VPWR VPWR sky130_fd_sc_hd__decap_3
XFILLER_53_330 VGND VGND VPWR VPWR sky130_fd_sc_hd__decap_3
X_2309_ my_mul.x2\[6\] _0623_ _0604_ VGND VGND VPWR VPWR _0631_ sky130_fd_sc_hd__a21o_1
XFILLER_38_360 VGND VGND VPWR VPWR sky130_fd_sc_hd__decap_3
XTAP_TAPCELL_ROW_0_131 VGND VPWR sky130_fd_sc_hd__tapvpwrvgnd_1
XPHY_EDGE_ROW_48_Right_48 VGND VGND VPWR VPWR sky130_fd_sc_hd__decap_3
XPHY_EDGE_ROW_57_Right_57 VGND VGND VPWR VPWR sky130_fd_sc_hd__decap_3
XFILLER_0_131 VGND VGND VPWR VPWR sky130_fd_sc_hd__decap_3
XFILLER_0_175 VGND VGND VPWR VPWR sky130_fd_sc_hd__decap_3
XFILLER_44_352 VGND VGND VPWR VPWR sky130_fd_sc_hd__decap_3
XFILLER_44_330 VGND VGND VPWR VPWR sky130_fd_sc_hd__decap_3
X_1611_ my_mul.x2\[5\] acc_reg\[5\] _1154_ VGND VGND VPWR VPWR _1155_ sky130_fd_sc_hd__and3_1
XFILLER_44_81 VGND VGND VPWR VPWR sky130_fd_sc_hd__decap_3
X_2660_ my_sum_sub.result\[15\] _1057_ _0958_ net148 VGND VGND VPWR VPWR _0291_ sky130_fd_sc_hd__a22o_1
XFILLER_8_253 VGND VGND VPWR VPWR sky130_fd_sc_hd__decap_3
XFILLER_8_275 VGND VGND VPWR VPWR sky130_fd_sc_hd__decap_3
XFILLER_12_293 VGND VGND VPWR VPWR sky130_fd_sc_hd__fill_1
X_2591_ _0861_ _0884_ _0885_ _0887_ VGND VGND VPWR VPWR _0890_ sky130_fd_sc_hd__or4_4
X_1542_ _1086_ state\[4\] VGND VGND VPWR VPWR _1087_ sky130_fd_sc_hd__and2b_1
XFILLER_35_330 VGND VGND VPWR VPWR sky130_fd_sc_hd__decap_3
X_2025_ _1088_ _0407_ _0430_ _1090_ VGND VGND VPWR VPWR _0431_ sky130_fd_sc_hd__a31o_1
X_3074_ clknet_4_14_0_clk net73 _0170_ VGND VGND VPWR VPWR my_sum_sub.cm_exp\[4\]
+ sky130_fd_sc_hd__dfrtp_2
X_3143_ clknet_4_0_0_clk _0239_ _0054_ VGND VGND VPWR VPWR bit_count\[0\] sky130_fd_sc_hd__dfrtp_1
X_2927_ net5 VGND VGND VPWR VPWR _0023_ sky130_fd_sc_hd__inv_2
XFILLER_24_29 VGND VGND VPWR VPWR sky130_fd_sc_hd__fill_1
X_1809_ _1351_ _1352_ VGND VGND VPWR VPWR _1353_ sky130_fd_sc_hd__nand2_1
X_2858_ net2 VGND VGND VPWR VPWR _0139_ sky130_fd_sc_hd__inv_2
Xhold253 acc_reg\[13\] VGND VGND VPWR VPWR net258 sky130_fd_sc_hd__dlygate4sd3_1
Xhold242 acc_reg\[15\] VGND VGND VPWR VPWR net247 sky130_fd_sc_hd__dlygate4sd3_1
Xhold231 _0245_ VGND VGND VPWR VPWR net236 sky130_fd_sc_hd__dlygate4sd3_1
Xhold220 my_divider.counter\[0\] VGND VGND VPWR VPWR net225 sky130_fd_sc_hd__dlygate4sd3_1
X_2789_ _1085_ ss_s1 my_sum_sub.done VGND VGND VPWR VPWR _1041_ sky130_fd_sc_hd__or3b_1
XFILLER_49_48 VGND VGND VPWR VPWR sky130_fd_sc_hd__decap_3
XFILLER_49_26 VGND VGND VPWR VPWR sky130_fd_sc_hd__decap_3
Xhold264 my_sum_sub.al_sa VGND VGND VPWR VPWR net269 sky130_fd_sc_hd__dlygate4sd3_1
Xhold297 acc_reg\[11\] VGND VGND VPWR VPWR net302 sky130_fd_sc_hd__dlygate4sd3_1
Xhold286 my_mul.reg1en.q\[0\] VGND VGND VPWR VPWR net291 sky130_fd_sc_hd__dlygate4sd3_1
Xhold275 state\[4\] VGND VGND VPWR VPWR net280 sky130_fd_sc_hd__dlygate4sd3_1
XFILLER_53_193 VGND VGND VPWR VPWR sky130_fd_sc_hd__fill_1
XFILLER_53_182 VGND VGND VPWR VPWR sky130_fd_sc_hd__decap_3
XFILLER_53_160 VGND VGND VPWR VPWR sky130_fd_sc_hd__decap_3
XFILLER_45_127 VGND VGND VPWR VPWR sky130_fd_sc_hd__decap_3
XFILLER_41_333 VGND VGND VPWR VPWR sky130_fd_sc_hd__decap_3
XTAP_TAPCELL_ROW_28_314 VGND VPWR sky130_fd_sc_hd__tapvpwrvgnd_1
XFILLER_41_344 VGND VGND VPWR VPWR sky130_fd_sc_hd__decap_3
XFILLER_14_73 VGND VGND VPWR VPWR sky130_fd_sc_hd__fill_1
XFILLER_39_9 VGND VGND VPWR VPWR sky130_fd_sc_hd__decap_3
XFILLER_30_83 VGND VGND VPWR VPWR sky130_fd_sc_hd__fill_1
XFILLER_55_91 VGND VGND VPWR VPWR sky130_fd_sc_hd__decap_3
XFILLER_32_344 VGND VGND VPWR VPWR sky130_fd_sc_hd__decap_3
X_2712_ _0986_ _0987_ VGND VGND VPWR VPWR _0988_ sky130_fd_sc_hd__nor2_1
X_2574_ _0835_ _0872_ _0849_ VGND VGND VPWR VPWR _0873_ sky130_fd_sc_hd__o21a_1
X_2643_ _0941_ VGND VGND VPWR VPWR _0942_ sky130_fd_sc_hd__inv_2
X_1525_ net283 _1074_ VGND VGND VPWR VPWR _1075_ sky130_fd_sc_hd__nand2_1
X_3057_ clknet_4_9_0_clk net270 _0153_ VGND VGND VPWR VPWR my_sum_sub.al_sa sky130_fd_sc_hd__dfrtp_4
X_2008_ _1107_ _0403_ VGND VGND VPWR VPWR _0416_ sky130_fd_sc_hd__xnor2_1
XFILLER_23_300 VGND VGND VPWR VPWR sky130_fd_sc_hd__fill_1
X_3126_ clknet_4_1_0_clk net32 _0037_ VGND VGND VPWR VPWR shift_in\[15\] sky130_fd_sc_hd__dfrtp_1
XFILLER_51_49 VGND VGND VPWR VPWR sky130_fd_sc_hd__decap_3
XFILLER_51_27 VGND VGND VPWR VPWR sky130_fd_sc_hd__decap_3
XFILLER_50_185 VGND VGND VPWR VPWR sky130_fd_sc_hd__decap_3
XFILLER_50_141 VGND VGND VPWR VPWR sky130_fd_sc_hd__decap_3
XTAP_TAPCELL_ROW_33_350 VGND VPWR sky130_fd_sc_hd__tapvpwrvgnd_1
XFILLER_23_344 VGND VGND VPWR VPWR sky130_fd_sc_hd__decap_3
XFILLER_23_333 VGND VGND VPWR VPWR sky130_fd_sc_hd__decap_3
XFILLER_4_6 VGND VGND VPWR VPWR sky130_fd_sc_hd__decap_3
XFILLER_58_274 VGND VGND VPWR VPWR sky130_fd_sc_hd__decap_3
XFILLER_58_241 VGND VGND VPWR VPWR sky130_fd_sc_hd__decap_3
XFILLER_18_116 VGND VGND VPWR VPWR sky130_fd_sc_hd__decap_3
XTAP_TAPCELL_ROW_56_497 VGND VPWR sky130_fd_sc_hd__tapvpwrvgnd_1
XFILLER_41_152 VGND VGND VPWR VPWR sky130_fd_sc_hd__decap_3
XFILLER_26_193 VGND VGND VPWR VPWR sky130_fd_sc_hd__decap_3
XFILLER_14_300 VGND VGND VPWR VPWR sky130_fd_sc_hd__decap_3
X_2290_ _1052_ acc_reg\[7\] _1124_ _1125_ VGND VGND VPWR VPWR _0613_ sky130_fd_sc_hd__o31a_1
XFILLER_37_6 VGND VGND VPWR VPWR sky130_fd_sc_hd__decap_3
XFILLER_1_281 VGND VGND VPWR VPWR sky130_fd_sc_hd__decap_3
XTAP_TAPCELL_ROW_47_442 VGND VPWR sky130_fd_sc_hd__tapvpwrvgnd_1
XTAP_TAPCELL_ROW_30_331 VGND VPWR sky130_fd_sc_hd__tapvpwrvgnd_1
X_2557_ _0815_ _0839_ VGND VGND VPWR VPWR _0856_ sky130_fd_sc_hd__nor2_1
X_2626_ net24 _0908_ _0923_ _0924_ VGND VGND VPWR VPWR _0925_ sky130_fd_sc_hd__a2bb2o_1
XFILLER_55_200 VGND VGND VPWR VPWR sky130_fd_sc_hd__decap_3
XFILLER_46_27 VGND VGND VPWR VPWR sky130_fd_sc_hd__fill_1
X_1508_ _1060_ net254 VGND VGND VPWR VPWR _1062_ sky130_fd_sc_hd__and2_1
X_2488_ _0768_ _0776_ _0785_ _0769_ VGND VGND VPWR VPWR _0787_ sky130_fd_sc_hd__o31a_1
XFILLER_62_15 VGND VGND VPWR VPWR sky130_fd_sc_hd__decap_3
XTAP_TAPCELL_ROW_53_478 VGND VPWR sky130_fd_sc_hd__tapvpwrvgnd_1
XFILLER_23_141 VGND VGND VPWR VPWR sky130_fd_sc_hd__fill_2
X_3109_ clknet_4_1_0_clk _0205_ _0020_ VGND VGND VPWR VPWR my_mul.x2\[14\] sky130_fd_sc_hd__dfrtp_2
XFILLER_11_325 VGND VGND VPWR VPWR sky130_fd_sc_hd__decap_3
XFILLER_2_3 VGND VGND VPWR VPWR sky130_fd_sc_hd__decap_3
XFILLER_46_266 VGND VGND VPWR VPWR sky130_fd_sc_hd__fill_2
XFILLER_46_244 VGND VGND VPWR VPWR sky130_fd_sc_hd__decap_3
XTAP_TAPCELL_ROW_44_423 VGND VPWR sky130_fd_sc_hd__tapvpwrvgnd_1
XFILLER_61_247 VGND VGND VPWR VPWR sky130_fd_sc_hd__decap_3
X_1790_ _1325_ _1333_ _1317_ VGND VGND VPWR VPWR _1334_ sky130_fd_sc_hd__o21a_1
XFILLER_52_81 VGND VGND VPWR VPWR sky130_fd_sc_hd__decap_3
XFILLER_36_93 VGND VGND VPWR VPWR sky130_fd_sc_hd__fill_1
X_2411_ _0702_ _0703_ _1053_ _0697_ VGND VGND VPWR VPWR _0710_ sky130_fd_sc_hd__a211o_1
XFILLER_6_340 VGND VGND VPWR VPWR sky130_fd_sc_hd__decap_3
XFILLER_6_362 VGND VGND VPWR VPWR sky130_fd_sc_hd__fill_2
X_2342_ _0659_ _0658_ _0604_ VGND VGND VPWR VPWR _0660_ sky130_fd_sc_hd__mux2_1
XFILLER_37_200 VGND VGND VPWR VPWR sky130_fd_sc_hd__decap_3
XFILLER_35_3 VGND VGND VPWR VPWR sky130_fd_sc_hd__decap_3
X_2273_ net127 net198 VGND VGND VPWR VPWR _0600_ sky130_fd_sc_hd__nor2_1
XFILLER_52_247 VGND VGND VPWR VPWR sky130_fd_sc_hd__decap_3
XFILLER_52_214 VGND VGND VPWR VPWR sky130_fd_sc_hd__decap_3
XFILLER_52_203 VGND VGND VPWR VPWR sky130_fd_sc_hd__fill_1
XFILLER_37_266 VGND VGND VPWR VPWR sky130_fd_sc_hd__decap_3
XFILLER_37_255 VGND VGND VPWR VPWR sky130_fd_sc_hd__fill_2
XFILLER_60_280 VGND VGND VPWR VPWR sky130_fd_sc_hd__decap_3
XTAP_TAPCELL_ROW_50_459 VGND VPWR sky130_fd_sc_hd__tapvpwrvgnd_1
X_1988_ _1126_ _0384_ VGND VGND VPWR VPWR _0397_ sky130_fd_sc_hd__xnor2_4
XFILLER_20_177 VGND VGND VPWR VPWR sky130_fd_sc_hd__fill_1
XFILLER_20_144 VGND VGND VPWR VPWR sky130_fd_sc_hd__fill_1
X_2609_ my_sum_sub.cm_mant\[2\] my_sum_sub.cm_mant\[1\] my_sum_sub.cm_mant\[0\] _0828_
+ VGND VGND VPWR VPWR _0908_ sky130_fd_sc_hd__or4_4
XTAP_TAPCELL_ROW_58_515 VGND VPWR sky130_fd_sc_hd__tapvpwrvgnd_1
Xclkbuf_4_5_0_clk clknet_0_clk VGND VGND VPWR VPWR clknet_4_5_0_clk sky130_fd_sc_hd__clkbuf_8
XFILLER_28_233 VGND VGND VPWR VPWR sky130_fd_sc_hd__fill_1
XFILLER_28_200 VGND VGND VPWR VPWR sky130_fd_sc_hd__fill_2
XFILLER_43_236 VGND VGND VPWR VPWR sky130_fd_sc_hd__fill_1
XTAP_TAPCELL_ROW_41_404 VGND VPWR sky130_fd_sc_hd__tapvpwrvgnd_1
XFILLER_11_111 VGND VGND VPWR VPWR sky130_fd_sc_hd__fill_1
XFILLER_3_332 VGND VGND VPWR VPWR sky130_fd_sc_hd__decap_3
XFILLER_47_70 VGND VGND VPWR VPWR sky130_fd_sc_hd__decap_3
XFILLER_19_277 VGND VGND VPWR VPWR sky130_fd_sc_hd__decap_3
X_2960_ net2 VGND VGND VPWR VPWR _0056_ sky130_fd_sc_hd__inv_2
X_1773_ _1299_ _1305_ VGND VGND VPWR VPWR _1317_ sky130_fd_sc_hd__xor2_1
X_1842_ _1383_ _1385_ VGND VGND VPWR VPWR _1386_ sky130_fd_sc_hd__and2_1
X_1911_ _1423_ _1448_ _1453_ _1454_ VGND VGND VPWR VPWR _1455_ sky130_fd_sc_hd__a211o_1
X_2891_ net2 VGND VGND VPWR VPWR _0172_ sky130_fd_sc_hd__inv_2
XFILLER_8_97 VGND VGND VPWR VPWR sky130_fd_sc_hd__decap_3
XFILLER_6_192 VGND VGND VPWR VPWR sky130_fd_sc_hd__fill_1
X_2325_ _0604_ _0643_ _0644_ _0622_ VGND VGND VPWR VPWR _0645_ sky130_fd_sc_hd__o211a_1
X_2256_ _0585_ _0527_ my_sum_sub.al_b_larger VGND VGND VPWR VPWR _0586_ sky130_fd_sc_hd__mux2_1
X_2187_ my_sum_sub.al_ma\[1\] my_sum_sub.al_mb\[1\] VGND VGND VPWR VPWR _0522_ sky130_fd_sc_hd__nand2b_1
XFILLER_25_225 VGND VGND VPWR VPWR sky130_fd_sc_hd__fill_2
XFILLER_0_368 VGND VGND VPWR VPWR sky130_fd_sc_hd__fill_2
XFILLER_0_346 VGND VGND VPWR VPWR sky130_fd_sc_hd__decap_3
XFILLER_0_324 VGND VGND VPWR VPWR sky130_fd_sc_hd__decap_3
XFILLER_0_302 VGND VGND VPWR VPWR sky130_fd_sc_hd__decap_3
XFILLER_56_350 VGND VGND VPWR VPWR sky130_fd_sc_hd__decap_3
XFILLER_3_184 VGND VGND VPWR VPWR sky130_fd_sc_hd__fill_1
XFILLER_3_173 VGND VGND VPWR VPWR sky130_fd_sc_hd__decap_3
XFILLER_3_140 VGND VGND VPWR VPWR sky130_fd_sc_hd__fill_1
XFILLER_58_91 VGND VGND VPWR VPWR sky130_fd_sc_hd__decap_3
XFILLER_47_361 VGND VGND VPWR VPWR sky130_fd_sc_hd__fill_1
X_2041_ net169 _1091_ _0444_ net280 VGND VGND VPWR VPWR _0445_ sky130_fd_sc_hd__o211a_1
X_2110_ net91 net83 net88 VGND VGND VPWR VPWR _0217_ sky130_fd_sc_hd__mux2_1
X_3090_ clknet_4_9_0_clk _0349_ _0186_ VGND VGND VPWR VPWR acc_reg\[11\] sky130_fd_sc_hd__dfrtp_4
X_2943_ net5 VGND VGND VPWR VPWR _0039_ sky130_fd_sc_hd__inv_2
X_1756_ _1290_ _1293_ _1291_ VGND VGND VPWR VPWR _1300_ sky130_fd_sc_hd__o21bai_1
X_1825_ _1367_ _1368_ VGND VGND VPWR VPWR _1369_ sky130_fd_sc_hd__xnor2_1
X_2874_ net2 VGND VGND VPWR VPWR _0155_ sky130_fd_sc_hd__inv_2
XFILLER_30_283 VGND VGND VPWR VPWR sky130_fd_sc_hd__decap_3
XFILLER_30_261 VGND VGND VPWR VPWR sky130_fd_sc_hd__fill_2
XFILLER_57_103 VGND VGND VPWR VPWR sky130_fd_sc_hd__decap_3
X_2308_ acc_reg\[6\] _0364_ VGND VGND VPWR VPWR _0630_ sky130_fd_sc_hd__and2_2
X_1687_ _1226_ _1230_ VGND VGND VPWR VPWR _1231_ sky130_fd_sc_hd__nand2_1
XFILLER_57_169 VGND VGND VPWR VPWR sky130_fd_sc_hd__decap_3
XFILLER_57_147 VGND VGND VPWR VPWR sky130_fd_sc_hd__fill_2
XFILLER_54_27 VGND VGND VPWR VPWR sky130_fd_sc_hd__fill_1
X_2239_ net293 _0572_ net127 VGND VGND VPWR VPWR _0326_ sky130_fd_sc_hd__mux2_1
XTAP_TAPCELL_ROW_0_132 VGND VPWR sky130_fd_sc_hd__tapvpwrvgnd_1
XFILLER_13_228 VGND VGND VPWR VPWR sky130_fd_sc_hd__fill_1
XFILLER_48_158 VGND VGND VPWR VPWR sky130_fd_sc_hd__decap_3
XFILLER_36_309 VGND VGND VPWR VPWR sky130_fd_sc_hd__fill_1
XFILLER_29_361 VGND VGND VPWR VPWR sky130_fd_sc_hd__decap_3
XFILLER_0_187 VGND VGND VPWR VPWR sky130_fd_sc_hd__decap_3
XTAP_TAPCELL_ROW_14_223 VGND VPWR sky130_fd_sc_hd__tapvpwrvgnd_1
X_1610_ my_mul.x2\[6\] acc_reg\[6\] VGND VGND VPWR VPWR _1154_ sky130_fd_sc_hd__xor2_1
X_2590_ _0883_ _0888_ VGND VGND VPWR VPWR _0889_ sky130_fd_sc_hd__nand2_1
XFILLER_12_250 VGND VGND VPWR VPWR sky130_fd_sc_hd__fill_2
X_3142_ clknet_4_3_0_clk net41 _0053_ VGND VGND VPWR VPWR shift_out\[15\] sky130_fd_sc_hd__dfrtp_1
X_1541_ my_mul.reg1en.q\[0\] _1084_ _1085_ my_sum_sub.done VGND VGND VPWR VPWR _1086_
+ sky130_fd_sc_hd__o22a_1
XFILLER_62_150 VGND VGND VPWR VPWR sky130_fd_sc_hd__decap_3
XFILLER_54_139 VGND VGND VPWR VPWR sky130_fd_sc_hd__fill_1
XFILLER_47_191 VGND VGND VPWR VPWR sky130_fd_sc_hd__decap_3
XFILLER_39_147 VGND VGND VPWR VPWR sky130_fd_sc_hd__fill_2
XFILLER_35_353 VGND VGND VPWR VPWR sky130_fd_sc_hd__decap_3
X_2024_ _0402_ _0429_ VGND VGND VPWR VPWR _0430_ sky130_fd_sc_hd__nand2_1
X_3073_ clknet_4_11_0_clk net128 _0169_ VGND VGND VPWR VPWR my_sum_sub.cm_exp\[3\]
+ sky130_fd_sc_hd__dfrtp_2
XFILLER_50_323 VGND VGND VPWR VPWR sky130_fd_sc_hd__decap_3
XFILLER_50_301 VGND VGND VPWR VPWR sky130_fd_sc_hd__decap_3
X_2857_ net2 VGND VGND VPWR VPWR _0138_ sky130_fd_sc_hd__inv_2
X_2926_ net5 VGND VGND VPWR VPWR _0022_ sky130_fd_sc_hd__inv_2
X_1808_ _1262_ _1323_ VGND VGND VPWR VPWR _1352_ sky130_fd_sc_hd__xnor2_1
Xhold232 my_sum_sub.al_mb\[6\] VGND VGND VPWR VPWR net237 sky130_fd_sc_hd__dlygate4sd3_1
X_1739_ _1277_ _1282_ VGND VGND VPWR VPWR _1283_ sky130_fd_sc_hd__nor2_1
Xhold265 _0316_ VGND VGND VPWR VPWR net270 sky130_fd_sc_hd__dlygate4sd3_1
Xhold287 acc_reg\[9\] VGND VGND VPWR VPWR net292 sky130_fd_sc_hd__dlygate4sd3_1
Xhold243 _0353_ VGND VGND VPWR VPWR net248 sky130_fd_sc_hd__dlygate4sd3_1
Xhold254 _0351_ VGND VGND VPWR VPWR net259 sky130_fd_sc_hd__dlygate4sd3_1
Xhold221 _0256_ VGND VGND VPWR VPWR net226 sky130_fd_sc_hd__dlygate4sd3_1
Xhold210 _0260_ VGND VGND VPWR VPWR net215 sky130_fd_sc_hd__dlygate4sd3_1
Xhold276 _1092_ VGND VGND VPWR VPWR net281 sky130_fd_sc_hd__dlygate4sd3_1
X_2788_ ss_s1 _1084_ VGND VGND VPWR VPWR _1040_ sky130_fd_sc_hd__nor2_1
XFILLER_49_38 VGND VGND VPWR VPWR sky130_fd_sc_hd__fill_1
XPHY_EDGE_ROW_37_Left_100 VGND VGND VPWR VPWR sky130_fd_sc_hd__decap_3
Xhold298 acc_reg\[7\] VGND VGND VPWR VPWR net303 sky130_fd_sc_hd__dlygate4sd3_1
XFILLER_53_172 VGND VGND VPWR VPWR sky130_fd_sc_hd__fill_1
XFILLER_41_356 VGND VGND VPWR VPWR sky130_fd_sc_hd__decap_3
XFILLER_41_323 VGND VGND VPWR VPWR sky130_fd_sc_hd__decap_3
XFILLER_38_191 VGND VGND VPWR VPWR sky130_fd_sc_hd__decap_3
XTAP_TAPCELL_ROW_36_370 VGND VPWR sky130_fd_sc_hd__tapvpwrvgnd_1
XTAP_TAPCELL_ROW_28_315 VGND VPWR sky130_fd_sc_hd__tapvpwrvgnd_1
XFILLER_5_213 VGND VGND VPWR VPWR sky130_fd_sc_hd__decap_3
XTAP_TAPCELL_ROW_11_204 VGND VPWR sky130_fd_sc_hd__tapvpwrvgnd_1
XFILLER_14_85 VGND VGND VPWR VPWR sky130_fd_sc_hd__fill_2
XFILLER_36_139 VGND VGND VPWR VPWR sky130_fd_sc_hd__fill_1
XFILLER_44_183 VGND VGND VPWR VPWR sky130_fd_sc_hd__decap_3
X_2711_ my_divider.remainder_reg\[2\] my_divider.divisor_reg\[2\] VGND VGND VPWR VPWR
+ _0987_ sky130_fd_sc_hd__and2b_1
X_1524_ net233 net187 net278 VGND VGND VPWR VPWR _1074_ sky130_fd_sc_hd__and3_1
X_2573_ _0837_ _0847_ VGND VGND VPWR VPWR _0872_ sky130_fd_sc_hd__or2_1
X_2642_ _1053_ _0910_ _0939_ _0940_ VGND VGND VPWR VPWR _0941_ sky130_fd_sc_hd__a22o_1
XFILLER_59_209 VGND VGND VPWR VPWR sky130_fd_sc_hd__decap_3
X_3125_ clknet_4_1_0_clk _0221_ _0036_ VGND VGND VPWR VPWR shift_in\[14\] sky130_fd_sc_hd__dfrtp_1
X_3056_ clknet_4_13_0_clk net135 _0152_ VGND VGND VPWR VPWR my_sum_sub.al_mb\[7\]
+ sky130_fd_sc_hd__dfrtp_1
XFILLER_50_120 VGND VGND VPWR VPWR sky130_fd_sc_hd__decap_3
XFILLER_35_172 VGND VGND VPWR VPWR sky130_fd_sc_hd__decap_3
X_2007_ _1431_ _1490_ _0414_ VGND VGND VPWR VPWR _0415_ sky130_fd_sc_hd__o21a_1
XFILLER_23_356 VGND VGND VPWR VPWR sky130_fd_sc_hd__decap_3
XFILLER_50_197 VGND VGND VPWR VPWR sky130_fd_sc_hd__decap_3
XFILLER_50_164 VGND VGND VPWR VPWR sky130_fd_sc_hd__decap_3
XTAP_TAPCELL_ROW_33_351 VGND VPWR sky130_fd_sc_hd__tapvpwrvgnd_1
X_2909_ net5 VGND VGND VPWR VPWR _0190_ sky130_fd_sc_hd__inv_2
XFILLER_58_286 VGND VGND VPWR VPWR sky130_fd_sc_hd__decap_3
XFILLER_58_253 VGND VGND VPWR VPWR sky130_fd_sc_hd__decap_3
XFILLER_58_231 VGND VGND VPWR VPWR sky130_fd_sc_hd__decap_3
XFILLER_58_220 VGND VGND VPWR VPWR sky130_fd_sc_hd__decap_3
XTAP_TAPCELL_ROW_56_498 VGND VPWR sky130_fd_sc_hd__tapvpwrvgnd_1
XFILLER_41_175 VGND VGND VPWR VPWR sky130_fd_sc_hd__decap_3
XFILLER_41_142 VGND VGND VPWR VPWR sky130_fd_sc_hd__decap_3
XFILLER_25_84 VGND VGND VPWR VPWR sky130_fd_sc_hd__decap_3
XFILLER_25_73 VGND VGND VPWR VPWR sky130_fd_sc_hd__decap_3
XFILLER_25_51 VGND VGND VPWR VPWR sky130_fd_sc_hd__decap_3
XFILLER_25_40 VGND VGND VPWR VPWR sky130_fd_sc_hd__decap_3
XFILLER_14_312 VGND VGND VPWR VPWR sky130_fd_sc_hd__fill_1
XFILLER_14_334 VGND VGND VPWR VPWR sky130_fd_sc_hd__decap_3
XFILLER_49_231 VGND VGND VPWR VPWR sky130_fd_sc_hd__decap_3
XFILLER_1_293 VGND VGND VPWR VPWR sky130_fd_sc_hd__decap_3
XTAP_TAPCELL_ROW_47_443 VGND VPWR sky130_fd_sc_hd__tapvpwrvgnd_1
XTAP_TAPCELL_ROW_30_332 VGND VPWR sky130_fd_sc_hd__tapvpwrvgnd_1
X_1507_ net2 VGND VGND VPWR VPWR _0085_ sky130_fd_sc_hd__inv_2
X_2556_ _0827_ _0853_ VGND VGND VPWR VPWR _0855_ sky130_fd_sc_hd__nand2_1
X_2625_ _0885_ _0913_ _0909_ VGND VGND VPWR VPWR _0924_ sky130_fd_sc_hd__o21a_1
X_2487_ _0780_ _0784_ VGND VGND VPWR VPWR _0786_ sky130_fd_sc_hd__and2b_1
XFILLER_55_234 VGND VGND VPWR VPWR sky130_fd_sc_hd__decap_3
XFILLER_55_212 VGND VGND VPWR VPWR sky130_fd_sc_hd__decap_3
X_3108_ clknet_4_4_0_clk _0204_ _0019_ VGND VGND VPWR VPWR my_mul.x2\[13\] sky130_fd_sc_hd__dfrtp_2
XFILLER_62_38 VGND VGND VPWR VPWR sky130_fd_sc_hd__decap_3
XFILLER_62_27 VGND VGND VPWR VPWR sky130_fd_sc_hd__fill_1
XTAP_TAPCELL_ROW_53_479 VGND VPWR sky130_fd_sc_hd__tapvpwrvgnd_1
X_3039_ clknet_4_11_0_clk net124 _0135_ VGND VGND VPWR VPWR my_sum_sub.al_exp\[6\]
+ sky130_fd_sc_hd__dfrtp_1
XFILLER_11_337 VGND VGND VPWR VPWR sky130_fd_sc_hd__decap_3
XFILLER_61_259 VGND VGND VPWR VPWR sky130_fd_sc_hd__decap_3
XFILLER_61_204 VGND VGND VPWR VPWR sky130_fd_sc_hd__fill_1
XFILLER_46_223 VGND VGND VPWR VPWR sky130_fd_sc_hd__decap_3
XTAP_TAPCELL_ROW_44_424 VGND VPWR sky130_fd_sc_hd__tapvpwrvgnd_1
XFILLER_52_93 VGND VGND VPWR VPWR sky130_fd_sc_hd__decap_3
XFILLER_52_71 VGND VGND VPWR VPWR sky130_fd_sc_hd__fill_1
XPHY_EDGE_ROW_26_Left_89 VGND VGND VPWR VPWR sky130_fd_sc_hd__decap_3
XFILLER_14_197 VGND VGND VPWR VPWR sky130_fd_sc_hd__decap_3
X_2341_ my_mul.x2\[2\] _0623_ VGND VGND VPWR VPWR _0659_ sky130_fd_sc_hd__and2_1
X_2410_ _0702_ _0703_ _0697_ VGND VGND VPWR VPWR _0709_ sky130_fd_sc_hd__a21o_1
X_2272_ _0597_ _0599_ net127 net276 VGND VGND VPWR VPWR _0320_ sky130_fd_sc_hd__o2bb2a_1
XFILLER_28_3 VGND VGND VPWR VPWR sky130_fd_sc_hd__decap_3
XFILLER_60_292 VGND VGND VPWR VPWR sky130_fd_sc_hd__decap_3
X_1987_ _1118_ _0386_ _1117_ VGND VGND VPWR VPWR _0396_ sky130_fd_sc_hd__a21o_1
X_2539_ _0837_ _0835_ VGND VGND VPWR VPWR _0838_ sky130_fd_sc_hd__and2b_1
X_2608_ _0871_ _0880_ _0905_ _0869_ VGND VGND VPWR VPWR _0907_ sky130_fd_sc_hd__a31oi_1
XFILLER_43_204 VGND VGND VPWR VPWR sky130_fd_sc_hd__decap_3
XFILLER_7_105 VGND VGND VPWR VPWR sky130_fd_sc_hd__decap_3
XFILLER_22_85 VGND VGND VPWR VPWR sky130_fd_sc_hd__fill_1
XFILLER_47_60 VGND VGND VPWR VPWR sky130_fd_sc_hd__decap_3
XTAP_TAPCELL_ROW_6_171 VGND VPWR sky130_fd_sc_hd__tapvpwrvgnd_1
X_1910_ _1390_ _1405_ VGND VGND VPWR VPWR _1454_ sky130_fd_sc_hd__xor2_1
XFILLER_34_259 VGND VGND VPWR VPWR sky130_fd_sc_hd__decap_3
X_2890_ net2 VGND VGND VPWR VPWR _0171_ sky130_fd_sc_hd__inv_2
X_1841_ _1364_ _1384_ VGND VGND VPWR VPWR _1385_ sky130_fd_sc_hd__nor2_1
X_1772_ _1310_ _1311_ VGND VGND VPWR VPWR _1316_ sky130_fd_sc_hd__xnor2_1
XFILLER_8_32 VGND VGND VPWR VPWR sky130_fd_sc_hd__decap_3
X_2324_ acc_reg\[4\] _0364_ _0605_ VGND VGND VPWR VPWR _0644_ sky130_fd_sc_hd__a21o_1
XFILLER_57_329 VGND VGND VPWR VPWR sky130_fd_sc_hd__decap_3
X_2186_ my_sum_sub.al_mb\[2\] my_sum_sub.al_ma\[2\] VGND VGND VPWR VPWR _0521_ sky130_fd_sc_hd__and2b_1
X_2255_ _0522_ _0536_ _0537_ _0521_ VGND VGND VPWR VPWR _0585_ sky130_fd_sc_hd__a31o_1
XFILLER_40_229 VGND VGND VPWR VPWR sky130_fd_sc_hd__decap_3
XFILLER_4_119 VGND VGND VPWR VPWR sky130_fd_sc_hd__fill_2
XFILLER_48_307 VGND VGND VPWR VPWR sky130_fd_sc_hd__fill_1
XTAP_TAPCELL_ROW_3_152 VGND VPWR sky130_fd_sc_hd__tapvpwrvgnd_1
XFILLER_0_358 VGND VGND VPWR VPWR sky130_fd_sc_hd__decap_3
XFILLER_56_362 VGND VGND VPWR VPWR sky130_fd_sc_hd__fill_2
XFILLER_62_321 VGND VGND VPWR VPWR sky130_fd_sc_hd__decap_3
XFILLER_58_81 VGND VGND VPWR VPWR sky130_fd_sc_hd__decap_3
X_2040_ _0368_ _0380_ _0441_ _0443_ VGND VGND VPWR VPWR _0444_ sky130_fd_sc_hd__a31o_1
XFILLER_62_365 VGND VGND VPWR VPWR sky130_fd_sc_hd__decap_3
XFILLER_62_343 VGND VGND VPWR VPWR sky130_fd_sc_hd__decap_3
XTAP_TAPCELL_ROW_60_522 VGND VPWR sky130_fd_sc_hd__tapvpwrvgnd_1
X_2942_ net5 VGND VGND VPWR VPWR _0038_ sky130_fd_sc_hd__inv_2
X_2873_ net2 VGND VGND VPWR VPWR _0154_ sky130_fd_sc_hd__inv_2
XFILLER_22_207 VGND VGND VPWR VPWR sky130_fd_sc_hd__decap_3
XTAP_TAPCELL_ROW_17_243 VGND VPWR sky130_fd_sc_hd__tapvpwrvgnd_1
X_1824_ my_mul.x2\[0\] acc_reg\[4\] VGND VGND VPWR VPWR _1368_ sky130_fd_sc_hd__nand2_1
X_1755_ _1289_ _1297_ VGND VGND VPWR VPWR _1299_ sky130_fd_sc_hd__xnor2_1
X_1686_ _1207_ _1222_ _1225_ VGND VGND VPWR VPWR _1230_ sky130_fd_sc_hd__nand3_1
Xclkbuf_4_4_0_clk clknet_0_clk VGND VGND VPWR VPWR clknet_4_4_0_clk sky130_fd_sc_hd__clkbuf_8
XPHY_EDGE_ROW_29_Left_92 VGND VGND VPWR VPWR sky130_fd_sc_hd__decap_3
X_2238_ _0542_ _0571_ VGND VGND VPWR VPWR _0572_ sky130_fd_sc_hd__xnor2_1
X_2307_ _0628_ VGND VGND VPWR VPWR _0629_ sky130_fd_sc_hd__inv_2
XFILLER_38_340 VGND VGND VPWR VPWR sky130_fd_sc_hd__decap_3
XFILLER_38_29 VGND VGND VPWR VPWR sky130_fd_sc_hd__decap_3
XPHY_EDGE_ROW_13_Left_76 VGND VGND VPWR VPWR sky130_fd_sc_hd__decap_3
XFILLER_53_343 VGND VGND VPWR VPWR sky130_fd_sc_hd__decap_3
XFILLER_53_321 VGND VGND VPWR VPWR sky130_fd_sc_hd__decap_3
X_2169_ net15 net103 my_sum_sub.state\[1\] VGND VGND VPWR VPWR _0331_ sky130_fd_sc_hd__mux2_1
XTAP_TAPCELL_ROW_0_133 VGND VPWR sky130_fd_sc_hd__tapvpwrvgnd_1
XFILLER_0_122 VGND VGND VPWR VPWR sky130_fd_sc_hd__decap_3
XFILLER_0_144 VGND VGND VPWR VPWR sky130_fd_sc_hd__decap_3
XFILLER_44_365 VGND VGND VPWR VPWR sky130_fd_sc_hd__decap_3
XFILLER_44_343 VGND VGND VPWR VPWR sky130_fd_sc_hd__fill_2
XFILLER_44_94 VGND VGND VPWR VPWR sky130_fd_sc_hd__decap_3
XTAP_TAPCELL_ROW_39_390 VGND VPWR sky130_fd_sc_hd__tapvpwrvgnd_1
XTAP_TAPCELL_ROW_14_224 VGND VPWR sky130_fd_sc_hd__tapvpwrvgnd_1
XFILLER_12_284 VGND VGND VPWR VPWR sky130_fd_sc_hd__decap_3
X_1540_ op_reg\[2\] net223 op_reg\[0\] VGND VGND VPWR VPWR _1085_ sky130_fd_sc_hd__or3_1
X_3141_ clknet_4_3_0_clk net39 _0052_ VGND VGND VPWR VPWR shift_out\[14\] sky130_fd_sc_hd__dfrtp_1
XFILLER_10_3 VGND VGND VPWR VPWR sky130_fd_sc_hd__decap_3
XFILLER_62_162 VGND VGND VPWR VPWR sky130_fd_sc_hd__decap_3
XFILLER_54_118 VGND VGND VPWR VPWR sky130_fd_sc_hd__fill_1
XFILLER_35_321 VGND VGND VPWR VPWR sky130_fd_sc_hd__decap_3
X_2023_ _1137_ _0396_ VGND VGND VPWR VPWR _0429_ sky130_fd_sc_hd__nand2_1
X_3072_ clknet_4_11_0_clk net104 _0168_ VGND VGND VPWR VPWR my_sum_sub.cm_exp\[2\]
+ sky130_fd_sc_hd__dfrtp_1
XFILLER_62_195 VGND VGND VPWR VPWR sky130_fd_sc_hd__fill_1
X_1807_ _1349_ _1350_ VGND VGND VPWR VPWR _1351_ sky130_fd_sc_hd__xnor2_1
XFILLER_50_368 VGND VGND VPWR VPWR sky130_fd_sc_hd__fill_2
X_2856_ net2 VGND VGND VPWR VPWR _0137_ sky130_fd_sc_hd__inv_2
X_2925_ net5 VGND VGND VPWR VPWR _0021_ sky130_fd_sc_hd__inv_2
X_1669_ _1211_ _1212_ my_mul.x2\[5\] acc_reg\[3\] VGND VGND VPWR VPWR _1213_ sky130_fd_sc_hd__and4bb_1
Xhold233 _0314_ VGND VGND VPWR VPWR net238 sky130_fd_sc_hd__dlygate4sd3_1
Xhold288 my_sum_sub.cm_mant\[7\] VGND VGND VPWR VPWR net293 sky130_fd_sc_hd__dlygate4sd3_1
X_1738_ _1260_ _1280_ VGND VGND VPWR VPWR _1282_ sky130_fd_sc_hd__xnor2_1
Xhold211 my_sum_sub.al_ma\[1\] VGND VGND VPWR VPWR net216 sky130_fd_sc_hd__dlygate4sd3_1
Xhold299 _0345_ VGND VGND VPWR VPWR net304 sky130_fd_sc_hd__dlygate4sd3_1
Xhold255 my_sum_sub.al_exp\[4\] VGND VGND VPWR VPWR net260 sky130_fd_sc_hd__dlygate4sd3_1
Xhold244 my_mul.x2\[12\] VGND VGND VPWR VPWR net249 sky130_fd_sc_hd__dlygate4sd3_1
Xhold277 my_sum_sub.state\[2\] VGND VGND VPWR VPWR net282 sky130_fd_sc_hd__dlygate4sd3_1
Xhold266 acc_reg\[12\] VGND VGND VPWR VPWR net271 sky130_fd_sc_hd__dlygate4sd3_1
Xhold222 state\[3\] VGND VGND VPWR VPWR net227 sky130_fd_sc_hd__dlygate4sd3_1
Xhold200 _0337_ VGND VGND VPWR VPWR net205 sky130_fd_sc_hd__dlygate4sd3_1
X_2787_ net159 net178 VGND VGND VPWR VPWR _0003_ sky130_fd_sc_hd__and2_1
XTAP_TAPCELL_ROW_28_316 VGND VPWR sky130_fd_sc_hd__tapvpwrvgnd_1
XFILLER_53_140 VGND VGND VPWR VPWR sky130_fd_sc_hd__fill_2
XTAP_TAPCELL_ROW_36_371 VGND VPWR sky130_fd_sc_hd__tapvpwrvgnd_1
XFILLER_5_225 VGND VGND VPWR VPWR sky130_fd_sc_hd__fill_1
XTAP_TAPCELL_ROW_11_205 VGND VPWR sky130_fd_sc_hd__tapvpwrvgnd_1
XFILLER_55_82 VGND VGND VPWR VPWR sky130_fd_sc_hd__decap_3
XFILLER_44_195 VGND VGND VPWR VPWR sky130_fd_sc_hd__fill_1
XFILLER_32_368 VGND VGND VPWR VPWR sky130_fd_sc_hd__fill_2
X_2710_ my_divider.divisor_reg\[2\] my_divider.remainder_reg\[2\] VGND VGND VPWR VPWR
+ _0986_ sky130_fd_sc_hd__and2b_1
XFILLER_58_3 VGND VGND VPWR VPWR sky130_fd_sc_hd__decap_3
X_1523_ _1070_ _1072_ VGND VGND VPWR VPWR _1073_ sky130_fd_sc_hd__nor2_1
XFILLER_4_280 VGND VGND VPWR VPWR sky130_fd_sc_hd__decap_3
X_2572_ _0844_ _0867_ _0870_ VGND VGND VPWR VPWR _0871_ sky130_fd_sc_hd__a21oi_1
X_2641_ _0910_ _0914_ VGND VGND VPWR VPWR _0940_ sky130_fd_sc_hd__nor2_1
X_3055_ clknet_4_13_0_clk net238 _0151_ VGND VGND VPWR VPWR my_sum_sub.al_mb\[6\]
+ sky130_fd_sc_hd__dfrtp_1
X_3124_ clknet_4_1_0_clk _0220_ _0035_ VGND VGND VPWR VPWR shift_in\[13\] sky130_fd_sc_hd__dfrtp_1
XFILLER_50_154 VGND VGND VPWR VPWR sky130_fd_sc_hd__decap_3
XFILLER_50_132 VGND VGND VPWR VPWR sky130_fd_sc_hd__decap_3
XFILLER_35_184 VGND VGND VPWR VPWR sky130_fd_sc_hd__decap_3
XTAP_TAPCELL_ROW_33_352 VGND VPWR sky130_fd_sc_hd__tapvpwrvgnd_1
X_2006_ _1432_ _1434_ _1489_ _0368_ VGND VGND VPWR VPWR _0414_ sky130_fd_sc_hd__o31a_1
XFILLER_23_368 VGND VGND VPWR VPWR sky130_fd_sc_hd__fill_2
XFILLER_50_176 VGND VGND VPWR VPWR sky130_fd_sc_hd__decap_3
X_2839_ net2 VGND VGND VPWR VPWR _0120_ sky130_fd_sc_hd__inv_2
X_2908_ net5 VGND VGND VPWR VPWR _0189_ sky130_fd_sc_hd__inv_2
XFILLER_58_298 VGND VGND VPWR VPWR sky130_fd_sc_hd__decap_3
XFILLER_58_265 VGND VGND VPWR VPWR sky130_fd_sc_hd__decap_3
XFILLER_26_173 VGND VGND VPWR VPWR sky130_fd_sc_hd__decap_3
XFILLER_18_107 VGND VGND VPWR VPWR sky130_fd_sc_hd__decap_3
XTAP_TAPCELL_ROW_56_499 VGND VPWR sky130_fd_sc_hd__tapvpwrvgnd_1
XFILLER_41_165 VGND VGND VPWR VPWR sky130_fd_sc_hd__decap_3
XFILLER_26_184 VGND VGND VPWR VPWR sky130_fd_sc_hd__decap_3
XFILLER_14_368 VGND VGND VPWR VPWR sky130_fd_sc_hd__fill_2
XFILLER_41_95 VGND VGND VPWR VPWR sky130_fd_sc_hd__fill_1
XPHY_EDGE_ROW_56_Left_119 VGND VGND VPWR VPWR sky130_fd_sc_hd__decap_3
XTAP_TAPCELL_ROW_30_333 VGND VPWR sky130_fd_sc_hd__tapvpwrvgnd_1
X_2624_ _0885_ _0913_ VGND VGND VPWR VPWR _0923_ sky130_fd_sc_hd__nand2_1
X_1506_ my_sum_sub.start VGND VGND VPWR VPWR _1061_ sky130_fd_sc_hd__inv_2
X_2555_ _0828_ _0852_ VGND VGND VPWR VPWR _0854_ sky130_fd_sc_hd__nor2_2
X_2486_ _0752_ _0780_ _0781_ _0784_ VGND VGND VPWR VPWR _0785_ sky130_fd_sc_hd__or4_4
XFILLER_55_246 VGND VGND VPWR VPWR sky130_fd_sc_hd__decap_3
XFILLER_46_29 VGND VGND VPWR VPWR sky130_fd_sc_hd__fill_1
X_3107_ clknet_4_4_0_clk net86 _0018_ VGND VGND VPWR VPWR my_mul.x2\[12\] sky130_fd_sc_hd__dfrtp_2
X_3038_ clknet_4_11_0_clk net250 _0134_ VGND VGND VPWR VPWR my_sum_sub.al_exp\[5\]
+ sky130_fd_sc_hd__dfrtp_1
XFILLER_11_305 VGND VGND VPWR VPWR sky130_fd_sc_hd__decap_3
XFILLER_11_316 VGND VGND VPWR VPWR sky130_fd_sc_hd__decap_3
XFILLER_11_349 VGND VGND VPWR VPWR sky130_fd_sc_hd__fill_2
XFILLER_11_54 VGND VGND VPWR VPWR sky130_fd_sc_hd__fill_2
XFILLER_61_238 VGND VGND VPWR VPWR sky130_fd_sc_hd__decap_3
XFILLER_46_235 VGND VGND VPWR VPWR sky130_fd_sc_hd__fill_1
XPHY_EDGE_ROW_1_Left_64 VGND VGND VPWR VPWR sky130_fd_sc_hd__decap_3
XFILLER_14_110 VGND VGND VPWR VPWR sky130_fd_sc_hd__fill_2
XFILLER_52_50 VGND VGND VPWR VPWR sky130_fd_sc_hd__fill_2
XFILLER_6_331 VGND VGND VPWR VPWR sky130_fd_sc_hd__decap_3
X_2340_ acc_reg\[2\] _0364_ VGND VGND VPWR VPWR _0658_ sky130_fd_sc_hd__and2_1
X_2271_ _0546_ _0554_ _0598_ net127 VGND VGND VPWR VPWR _0599_ sky130_fd_sc_hd__o31a_1
XTAP_TAPCELL_ROW_9_191 VGND VPWR sky130_fd_sc_hd__tapvpwrvgnd_1
XFILLER_37_246 VGND VGND VPWR VPWR sky130_fd_sc_hd__decap_3
XFILLER_60_271 VGND VGND VPWR VPWR sky130_fd_sc_hd__decap_3
X_1986_ _1117_ _1137_ VGND VGND VPWR VPWR _0395_ sky130_fd_sc_hd__xor2_1
XFILLER_20_168 VGND VGND VPWR VPWR sky130_fd_sc_hd__decap_3
X_2607_ _0871_ _0880_ _0905_ VGND VGND VPWR VPWR _0906_ sky130_fd_sc_hd__and3_1
X_2538_ _0811_ _0832_ _0833_ _0786_ VGND VGND VPWR VPWR _0837_ sky130_fd_sc_hd__a2bb2o_1
X_2469_ _0761_ _0762_ _0765_ VGND VGND VPWR VPWR _0768_ sky130_fd_sc_hd__nand3b_1
XFILLER_43_216 VGND VGND VPWR VPWR sky130_fd_sc_hd__decap_3
XFILLER_28_224 VGND VGND VPWR VPWR sky130_fd_sc_hd__decap_3
XFILLER_51_260 VGND VGND VPWR VPWR sky130_fd_sc_hd__fill_2
XFILLER_3_323 VGND VGND VPWR VPWR sky130_fd_sc_hd__decap_3
XFILLER_3_301 VGND VGND VPWR VPWR sky130_fd_sc_hd__decap_3
XFILLER_47_94 VGND VGND VPWR VPWR sky130_fd_sc_hd__decap_3
XFILLER_19_257 VGND VGND VPWR VPWR sky130_fd_sc_hd__decap_3
XFILLER_19_235 VGND VGND VPWR VPWR sky130_fd_sc_hd__fill_1
XTAP_TAPCELL_ROW_6_172 VGND VPWR sky130_fd_sc_hd__tapvpwrvgnd_1
X_1840_ my_mul.x2\[2\] acc_reg\[1\] acc_reg\[0\] my_mul.x2\[3\] VGND VGND VPWR VPWR
+ _1384_ sky130_fd_sc_hd__a22oi_1
XFILLER_42_282 VGND VGND VPWR VPWR sky130_fd_sc_hd__fill_1
XFILLER_34_249 VGND VGND VPWR VPWR sky130_fd_sc_hd__decap_3
X_1771_ _1314_ VGND VGND VPWR VPWR _1315_ sky130_fd_sc_hd__inv_2
XFILLER_6_150 VGND VGND VPWR VPWR sky130_fd_sc_hd__decap_3
XFILLER_8_77 VGND VGND VPWR VPWR sky130_fd_sc_hd__decap_3
XFILLER_57_308 VGND VGND VPWR VPWR sky130_fd_sc_hd__decap_3
X_2254_ net264 _0584_ net127 VGND VGND VPWR VPWR _0323_ sky130_fd_sc_hd__mux2_1
X_2323_ my_mul.x2\[4\] _0623_ VGND VGND VPWR VPWR _0643_ sky130_fd_sc_hd__and2_1
X_2185_ my_sum_sub.al_ma\[2\] my_sum_sub.al_mb\[2\] VGND VGND VPWR VPWR _0520_ sky130_fd_sc_hd__and2b_1
XFILLER_25_216 VGND VGND VPWR VPWR sky130_fd_sc_hd__decap_3
XFILLER_18_290 VGND VGND VPWR VPWR sky130_fd_sc_hd__fill_1
X_1969_ _1461_ _1467_ _1477_ _0377_ VGND VGND VPWR VPWR _0378_ sky130_fd_sc_hd__or4_1
XFILLER_0_337 VGND VGND VPWR VPWR sky130_fd_sc_hd__decap_3
XFILLER_0_315 VGND VGND VPWR VPWR sky130_fd_sc_hd__decap_3
XTAP_TAPCELL_ROW_3_153 VGND VPWR sky130_fd_sc_hd__tapvpwrvgnd_1
XFILLER_58_60 VGND VGND VPWR VPWR sky130_fd_sc_hd__decap_3
XFILLER_3_153 VGND VGND VPWR VPWR sky130_fd_sc_hd__decap_3
XFILLER_62_355 VGND VGND VPWR VPWR sky130_fd_sc_hd__decap_3
XFILLER_62_333 VGND VGND VPWR VPWR sky130_fd_sc_hd__decap_3
XFILLER_59_190 VGND VGND VPWR VPWR sky130_fd_sc_hd__decap_3
XFILLER_47_352 VGND VGND VPWR VPWR sky130_fd_sc_hd__fill_1
XTAP_TAPCELL_ROW_17_244 VGND VPWR sky130_fd_sc_hd__tapvpwrvgnd_1
XTAP_TAPCELL_ROW_60_523 VGND VPWR sky130_fd_sc_hd__tapvpwrvgnd_1
X_1823_ _1364_ _1365_ VGND VGND VPWR VPWR _1367_ sky130_fd_sc_hd__xnor2_1
X_2872_ net5 VGND VGND VPWR VPWR _0153_ sky130_fd_sc_hd__inv_2
X_2941_ net2 VGND VGND VPWR VPWR _0037_ sky130_fd_sc_hd__inv_2
XFILLER_15_260 VGND VGND VPWR VPWR sky130_fd_sc_hd__fill_1
X_1754_ _1289_ _1297_ VGND VGND VPWR VPWR _1298_ sky130_fd_sc_hd__nand2_1
X_1685_ _1226_ _1228_ VGND VGND VPWR VPWR _1229_ sky130_fd_sc_hd__nor2_1
XFILLER_57_116 VGND VGND VPWR VPWR sky130_fd_sc_hd__decap_3
X_2237_ _0546_ _0566_ _0570_ _0565_ VGND VGND VPWR VPWR _0571_ sky130_fd_sc_hd__a31o_1
X_2306_ _0397_ _0627_ VGND VGND VPWR VPWR _0628_ sky130_fd_sc_hd__xnor2_4
XFILLER_38_363 VGND VGND VPWR VPWR sky130_fd_sc_hd__fill_1
XFILLER_54_29 VGND VGND VPWR VPWR sky130_fd_sc_hd__fill_1
XFILLER_54_18 VGND VGND VPWR VPWR sky130_fd_sc_hd__decap_3
XFILLER_53_333 VGND VGND VPWR VPWR sky130_fd_sc_hd__decap_3
X_2099_ _0458_ _0493_ VGND VGND VPWR VPWR _0494_ sky130_fd_sc_hd__nor2_1
X_2168_ net11 net98 net127 VGND VGND VPWR VPWR _0332_ sky130_fd_sc_hd__mux2_1
XTAP_TAPCELL_ROW_0_134 VGND VPWR sky130_fd_sc_hd__tapvpwrvgnd_1
XPHY_EDGE_ROW_17_Right_17 VGND VGND VPWR VPWR sky130_fd_sc_hd__decap_3
XPHY_EDGE_ROW_26_Right_26 VGND VGND VPWR VPWR sky130_fd_sc_hd__decap_3
XFILLER_0_134 VGND VGND VPWR VPWR sky130_fd_sc_hd__decap_3
XFILLER_0_178 VGND VGND VPWR VPWR sky130_fd_sc_hd__decap_3
XFILLER_56_182 VGND VGND VPWR VPWR sky130_fd_sc_hd__decap_3
XFILLER_48_127 VGND VGND VPWR VPWR sky130_fd_sc_hd__decap_3
XFILLER_44_355 VGND VGND VPWR VPWR sky130_fd_sc_hd__fill_1
XFILLER_44_333 VGND VGND VPWR VPWR sky130_fd_sc_hd__fill_1
XTAP_TAPCELL_ROW_39_391 VGND VPWR sky130_fd_sc_hd__tapvpwrvgnd_1
XFILLER_28_41 VGND VGND VPWR VPWR sky130_fd_sc_hd__fill_1
XPHY_EDGE_ROW_35_Right_35 VGND VGND VPWR VPWR sky130_fd_sc_hd__decap_3
XFILLER_8_212 VGND VGND VPWR VPWR sky130_fd_sc_hd__decap_3
XTAP_TAPCELL_ROW_14_225 VGND VPWR sky130_fd_sc_hd__tapvpwrvgnd_1
XFILLER_60_61 VGND VGND VPWR VPWR sky130_fd_sc_hd__decap_3
XPHY_EDGE_ROW_30_Left_93 VGND VGND VPWR VPWR sky130_fd_sc_hd__decap_3
XTAP_TAPCELL_ROW_22_280 VGND VPWR sky130_fd_sc_hd__tapvpwrvgnd_1
XFILLER_8_256 VGND VGND VPWR VPWR sky130_fd_sc_hd__decap_3
XFILLER_8_278 VGND VGND VPWR VPWR sky130_fd_sc_hd__decap_3
XPHY_EDGE_ROW_44_Right_44 VGND VGND VPWR VPWR sky130_fd_sc_hd__decap_3
X_3071_ clknet_4_14_0_clk net114 _0167_ VGND VGND VPWR VPWR my_sum_sub.cm_exp\[1\]
+ sky130_fd_sc_hd__dfrtp_2
X_3140_ clknet_4_9_0_clk net65 _0051_ VGND VGND VPWR VPWR shift_out\[13\] sky130_fd_sc_hd__dfrtp_1
XFILLER_62_141 VGND VGND VPWR VPWR sky130_fd_sc_hd__decap_3
XPHY_EDGE_ROW_53_Right_53 VGND VGND VPWR VPWR sky130_fd_sc_hd__decap_3
XFILLER_50_314 VGND VGND VPWR VPWR sky130_fd_sc_hd__decap_3
XFILLER_47_182 VGND VGND VPWR VPWR sky130_fd_sc_hd__decap_3
X_2022_ _0375_ _0376_ _0373_ VGND VGND VPWR VPWR _0428_ sky130_fd_sc_hd__a21o_1
XFILLER_35_333 VGND VGND VPWR VPWR sky130_fd_sc_hd__decap_3
X_1806_ my_mul.x2\[0\] acc_reg\[5\] VGND VGND VPWR VPWR _1350_ sky130_fd_sc_hd__nand2_1
Xhold201 my_sum_sub.al_ma\[2\] VGND VGND VPWR VPWR net206 sky130_fd_sc_hd__dlygate4sd3_1
X_2924_ net5 VGND VGND VPWR VPWR _0020_ sky130_fd_sc_hd__inv_2
X_2855_ net2 VGND VGND VPWR VPWR _0136_ sky130_fd_sc_hd__inv_2
X_2786_ net227 _1076_ _1096_ VGND VGND VPWR VPWR _0005_ sky130_fd_sc_hd__and3_1
XPHY_EDGE_ROW_62_Right_62 VGND VGND VPWR VPWR sky130_fd_sc_hd__decap_3
X_1668_ my_mul.x2\[6\] acc_reg\[2\] acc_reg\[1\] VGND VGND VPWR VPWR _1212_ sky130_fd_sc_hd__a21oi_1
X_1737_ _1260_ _1280_ VGND VGND VPWR VPWR _1281_ sky130_fd_sc_hd__and2_1
XFILLER_49_29 VGND VGND VPWR VPWR sky130_fd_sc_hd__decap_3
Xhold212 my_sum_sub.al_mb\[0\] VGND VGND VPWR VPWR net217 sky130_fd_sc_hd__dlygate4sd3_1
Xhold289 acc_reg\[8\] VGND VGND VPWR VPWR net294 sky130_fd_sc_hd__dlygate4sd3_1
Xhold256 _0692_ VGND VGND VPWR VPWR net261 sky130_fd_sc_hd__dlygate4sd3_1
Xhold245 _0297_ VGND VGND VPWR VPWR net250 sky130_fd_sc_hd__dlygate4sd3_1
X_1599_ _1142_ _1109_ VGND VGND VPWR VPWR _1143_ sky130_fd_sc_hd__and2b_1
Xhold267 _0350_ VGND VGND VPWR VPWR net272 sky130_fd_sc_hd__dlygate4sd3_1
Xhold278 bit_count\[3\] VGND VGND VPWR VPWR net283 sky130_fd_sc_hd__dlygate4sd3_1
Xhold223 _0005_ VGND VGND VPWR VPWR net228 sky130_fd_sc_hd__dlygate4sd3_1
Xhold234 shift_in\[6\] VGND VGND VPWR VPWR net239 sky130_fd_sc_hd__dlygate4sd3_1
XFILLER_38_171 VGND VGND VPWR VPWR sky130_fd_sc_hd__decap_3
XTAP_TAPCELL_ROW_28_317 VGND VPWR sky130_fd_sc_hd__tapvpwrvgnd_1
XFILLER_53_163 VGND VGND VPWR VPWR sky130_fd_sc_hd__decap_3
XFILLER_41_347 VGND VGND VPWR VPWR sky130_fd_sc_hd__decap_3
XTAP_TAPCELL_ROW_36_372 VGND VPWR sky130_fd_sc_hd__tapvpwrvgnd_1
XTAP_TAPCELL_ROW_11_206 VGND VPWR sky130_fd_sc_hd__tapvpwrvgnd_1
XFILLER_30_97 VGND VGND VPWR VPWR sky130_fd_sc_hd__fill_2
XFILLER_30_42 VGND VGND VPWR VPWR sky130_fd_sc_hd__decap_3
Xclkbuf_4_3_0_clk clknet_0_clk VGND VGND VPWR VPWR clknet_4_3_0_clk sky130_fd_sc_hd__clkbuf_8
XFILLER_55_50 VGND VGND VPWR VPWR sky130_fd_sc_hd__decap_3
XFILLER_44_130 VGND VGND VPWR VPWR sky130_fd_sc_hd__fill_1
XFILLER_32_347 VGND VGND VPWR VPWR sky130_fd_sc_hd__fill_1
XFILLER_17_300 VGND VGND VPWR VPWR sky130_fd_sc_hd__fill_2
XFILLER_17_311 VGND VGND VPWR VPWR sky130_fd_sc_hd__decap_3
X_2640_ _0885_ _0913_ _0938_ _0882_ VGND VGND VPWR VPWR _0939_ sky130_fd_sc_hd__o22ai_1
XFILLER_4_292 VGND VGND VPWR VPWR sky130_fd_sc_hd__decap_3
X_1522_ _1071_ VGND VGND VPWR VPWR _1072_ sky130_fd_sc_hd__inv_2
X_2571_ _0855_ _0861_ _0865_ _0843_ VGND VGND VPWR VPWR _0870_ sky130_fd_sc_hd__o31a_1
X_3054_ clknet_4_13_0_clk net132 _0150_ VGND VGND VPWR VPWR my_sum_sub.al_mb\[5\]
+ sky130_fd_sc_hd__dfrtp_1
XFILLER_27_108 VGND VGND VPWR VPWR sky130_fd_sc_hd__decap_3
X_3123_ clknet_4_4_0_clk _0219_ _0034_ VGND VGND VPWR VPWR shift_in\[12\] sky130_fd_sc_hd__dfrtp_1
X_2005_ net38 _1099_ _0412_ _0413_ VGND VGND VPWR VPWR _0237_ sky130_fd_sc_hd__o22a_1
XFILLER_50_188 VGND VGND VPWR VPWR sky130_fd_sc_hd__decap_3
XFILLER_50_144 VGND VGND VPWR VPWR sky130_fd_sc_hd__fill_2
XFILLER_50_100 VGND VGND VPWR VPWR sky130_fd_sc_hd__fill_1
XFILLER_35_163 VGND VGND VPWR VPWR sky130_fd_sc_hd__decap_3
X_2907_ net5 VGND VGND VPWR VPWR _0188_ sky130_fd_sc_hd__inv_2
X_2769_ net108 _1033_ VGND VGND VPWR VPWR _1035_ sky130_fd_sc_hd__and2_1
X_2838_ net2 VGND VGND VPWR VPWR _0119_ sky130_fd_sc_hd__inv_2
XFILLER_58_244 VGND VGND VPWR VPWR sky130_fd_sc_hd__decap_3
XFILLER_58_211 VGND VGND VPWR VPWR sky130_fd_sc_hd__decap_3
XFILLER_58_200 VGND VGND VPWR VPWR sky130_fd_sc_hd__decap_3
XFILLER_4_9 VGND VGND VPWR VPWR sky130_fd_sc_hd__decap_3
XFILLER_58_277 VGND VGND VPWR VPWR sky130_fd_sc_hd__decap_3
XFILLER_26_152 VGND VGND VPWR VPWR sky130_fd_sc_hd__decap_3
XFILLER_26_141 VGND VGND VPWR VPWR sky130_fd_sc_hd__fill_1
XFILLER_14_303 VGND VGND VPWR VPWR sky130_fd_sc_hd__decap_3
XFILLER_41_155 VGND VGND VPWR VPWR sky130_fd_sc_hd__decap_3
XFILLER_41_74 VGND VGND VPWR VPWR sky130_fd_sc_hd__fill_1
XFILLER_37_9 VGND VGND VPWR VPWR sky130_fd_sc_hd__decap_3
XFILLER_1_284 VGND VGND VPWR VPWR sky130_fd_sc_hd__decap_3
XFILLER_32_177 VGND VGND VPWR VPWR sky130_fd_sc_hd__fill_2
XFILLER_17_163 VGND VGND VPWR VPWR sky130_fd_sc_hd__fill_2
X_2554_ _0852_ VGND VGND VPWR VPWR _0853_ sky130_fd_sc_hd__inv_2
X_2623_ _0921_ VGND VGND VPWR VPWR _0922_ sky130_fd_sc_hd__inv_2
X_1505_ net202 VGND VGND VPWR VPWR _1060_ sky130_fd_sc_hd__inv_2
X_2485_ _0722_ _0749_ _0723_ VGND VGND VPWR VPWR _0784_ sky130_fd_sc_hd__o21a_1
XFILLER_62_18 VGND VGND VPWR VPWR sky130_fd_sc_hd__decap_3
XFILLER_55_225 VGND VGND VPWR VPWR sky130_fd_sc_hd__decap_3
XFILLER_55_203 VGND VGND VPWR VPWR sky130_fd_sc_hd__decap_3
X_3106_ clknet_4_4_0_clk _0202_ _0017_ VGND VGND VPWR VPWR my_mul.x2\[11\] sky130_fd_sc_hd__dfrtp_4
X_3037_ clknet_4_11_0_clk _0296_ _0133_ VGND VGND VPWR VPWR my_sum_sub.al_exp\[4\]
+ sky130_fd_sc_hd__dfrtp_1
XFILLER_23_111 VGND VGND VPWR VPWR sky130_fd_sc_hd__fill_1
XFILLER_62_29 VGND VGND VPWR VPWR sky130_fd_sc_hd__decap_3
XFILLER_23_177 VGND VGND VPWR VPWR sky130_fd_sc_hd__fill_2
XFILLER_11_328 VGND VGND VPWR VPWR sky130_fd_sc_hd__decap_3
XFILLER_2_6 VGND VGND VPWR VPWR sky130_fd_sc_hd__decap_3
XFILLER_11_66 VGND VGND VPWR VPWR sky130_fd_sc_hd__fill_2
XFILLER_46_247 VGND VGND VPWR VPWR sky130_fd_sc_hd__decap_3
XTAP_TAPCELL_ROW_52_470 VGND VPWR sky130_fd_sc_hd__tapvpwrvgnd_1
XFILLER_52_62 VGND VGND VPWR VPWR sky130_fd_sc_hd__decap_3
XFILLER_6_321 VGND VGND VPWR VPWR sky130_fd_sc_hd__decap_3
XFILLER_6_343 VGND VGND VPWR VPWR sky130_fd_sc_hd__decap_3
XFILLER_6_365 VGND VGND VPWR VPWR sky130_fd_sc_hd__decap_3
X_2270_ net217 net273 _0524_ VGND VGND VPWR VPWR _0598_ sky130_fd_sc_hd__a21oi_1
XFILLER_35_6 VGND VGND VPWR VPWR sky130_fd_sc_hd__decap_3
XTAP_TAPCELL_ROW_9_192 VGND VPWR sky130_fd_sc_hd__tapvpwrvgnd_1
XFILLER_52_217 VGND VGND VPWR VPWR sky130_fd_sc_hd__decap_3
XFILLER_37_225 VGND VGND VPWR VPWR sky130_fd_sc_hd__decap_3
XFILLER_37_203 VGND VGND VPWR VPWR sky130_fd_sc_hd__decap_3
XFILLER_60_283 VGND VGND VPWR VPWR sky130_fd_sc_hd__decap_3
X_1985_ _0393_ VGND VGND VPWR VPWR _0394_ sky130_fd_sc_hd__inv_2
X_2537_ _0835_ VGND VGND VPWR VPWR _0836_ sky130_fd_sc_hd__inv_2
X_2606_ _0890_ _0904_ VGND VGND VPWR VPWR _0905_ sky130_fd_sc_hd__and2b_2
X_2399_ my_sum_sub.cm_exp\[1\] my_sum_sub.cm_exp\[0\] my_sum_sub.cm_mant\[8\] VGND
+ VGND VPWR VPWR _0698_ sky130_fd_sc_hd__and3_1
X_2468_ _0761_ _0762_ _0765_ VGND VGND VPWR VPWR _0767_ sky130_fd_sc_hd__and3b_1
XFILLER_3_368 VGND VGND VPWR VPWR sky130_fd_sc_hd__fill_2
XFILLER_3_335 VGND VGND VPWR VPWR sky130_fd_sc_hd__fill_1
XFILLER_0_3 VGND VGND VPWR VPWR sky130_fd_sc_hd__decap_3
XFILLER_59_361 VGND VGND VPWR VPWR sky130_fd_sc_hd__decap_3
XFILLER_47_73 VGND VGND VPWR VPWR sky130_fd_sc_hd__decap_3
XTAP_TAPCELL_ROW_6_173 VGND VPWR sky130_fd_sc_hd__tapvpwrvgnd_1
X_1770_ _1287_ _1312_ VGND VGND VPWR VPWR _1314_ sky130_fd_sc_hd__xnor2_1
XFILLER_42_272 VGND VGND VPWR VPWR sky130_fd_sc_hd__fill_2
XFILLER_42_250 VGND VGND VPWR VPWR sky130_fd_sc_hd__fill_2
X_2322_ my_sum_sub.state\[2\] net131 _0642_ VGND VGND VPWR VPWR _0313_ sky130_fd_sc_hd__o21a_1
X_2253_ _0534_ _0583_ VGND VGND VPWR VPWR _0584_ sky130_fd_sc_hd__xnor2_1
X_2184_ _0518_ VGND VGND VPWR VPWR _0519_ sky130_fd_sc_hd__inv_2
XFILLER_33_3 VGND VGND VPWR VPWR sky130_fd_sc_hd__decap_3
X_1968_ _1468_ _1469_ _1484_ VGND VGND VPWR VPWR _0377_ sky130_fd_sc_hd__or3_1
X_1899_ _1123_ _1132_ _1135_ VGND VGND VPWR VPWR _1443_ sky130_fd_sc_hd__or3_1
XFILLER_0_349 VGND VGND VPWR VPWR sky130_fd_sc_hd__decap_3
XFILLER_0_327 VGND VGND VPWR VPWR sky130_fd_sc_hd__decap_3
XFILLER_0_305 VGND VGND VPWR VPWR sky130_fd_sc_hd__decap_3
XFILLER_56_353 VGND VGND VPWR VPWR sky130_fd_sc_hd__decap_3
XFILLER_56_331 VGND VGND VPWR VPWR sky130_fd_sc_hd__fill_1
XTAP_TAPCELL_ROW_3_154 VGND VPWR sky130_fd_sc_hd__tapvpwrvgnd_1
XFILLER_16_228 VGND VGND VPWR VPWR sky130_fd_sc_hd__decap_3
XFILLER_17_21 VGND VGND VPWR VPWR sky130_fd_sc_hd__decap_3
XFILLER_24_250 VGND VGND VPWR VPWR sky130_fd_sc_hd__fill_2
XFILLER_33_97 VGND VGND VPWR VPWR sky130_fd_sc_hd__decap_3
XFILLER_3_121 VGND VGND VPWR VPWR sky130_fd_sc_hd__fill_2
XFILLER_58_94 VGND VGND VPWR VPWR sky130_fd_sc_hd__decap_3
XFILLER_3_176 VGND VGND VPWR VPWR sky130_fd_sc_hd__fill_2
XFILLER_62_312 VGND VGND VPWR VPWR sky130_fd_sc_hd__decap_3
X_2940_ net2 VGND VGND VPWR VPWR _0036_ sky130_fd_sc_hd__inv_2
XTAP_TAPCELL_ROW_17_245 VGND VPWR sky130_fd_sc_hd__tapvpwrvgnd_1
X_1753_ _1263_ _1294_ _1295_ VGND VGND VPWR VPWR _1297_ sky130_fd_sc_hd__and3_1
XTAP_TAPCELL_ROW_60_524 VGND VPWR sky130_fd_sc_hd__tapvpwrvgnd_1
X_1822_ my_mul.x2\[1\] acc_reg\[3\] _1364_ VGND VGND VPWR VPWR _1366_ sky130_fd_sc_hd__and3_1
X_2871_ net2 VGND VGND VPWR VPWR _0152_ sky130_fd_sc_hd__inv_2
XFILLER_30_286 VGND VGND VPWR VPWR sky130_fd_sc_hd__fill_1
X_1684_ _1206_ _1227_ VGND VGND VPWR VPWR _1228_ sky130_fd_sc_hd__nand2_1
XFILLER_57_106 VGND VGND VPWR VPWR sky130_fd_sc_hd__decap_3
X_2236_ my_sum_sub.al_b_larger _0532_ _0569_ _0511_ VGND VGND VPWR VPWR _0570_ sky130_fd_sc_hd__o2bb2a_1
XFILLER_53_312 VGND VGND VPWR VPWR sky130_fd_sc_hd__decap_3
X_2305_ _1153_ _0604_ VGND VGND VPWR VPWR _0627_ sky130_fd_sc_hd__or2_2
X_2167_ net72 my_sum_sub.al_exp\[4\] my_sum_sub.state\[1\] VGND VGND VPWR VPWR _0333_
+ sky130_fd_sc_hd__mux2_1
XTAP_TAPCELL_ROW_0_135 VGND VPWR sky130_fd_sc_hd__tapvpwrvgnd_1
XFILLER_53_367 VGND VGND VPWR VPWR sky130_fd_sc_hd__decap_3
X_2098_ _1456_ _1461_ _1462_ _1487_ VGND VGND VPWR VPWR _0493_ sky130_fd_sc_hd__a22o_1
XFILLER_48_139 VGND VGND VPWR VPWR sky130_fd_sc_hd__fill_1
XFILLER_0_113 VGND VGND VPWR VPWR sky130_fd_sc_hd__decap_3
XFILLER_56_194 VGND VGND VPWR VPWR sky130_fd_sc_hd__fill_2
XFILLER_44_312 VGND VGND VPWR VPWR sky130_fd_sc_hd__decap_3
XFILLER_29_364 VGND VGND VPWR VPWR sky130_fd_sc_hd__decap_3
XTAP_TAPCELL_ROW_22_281 VGND VPWR sky130_fd_sc_hd__tapvpwrvgnd_1
XTAP_TAPCELL_ROW_14_226 VGND VPWR sky130_fd_sc_hd__tapvpwrvgnd_1
XFILLER_5_68 VGND VGND VPWR VPWR sky130_fd_sc_hd__decap_3
XFILLER_54_109 VGND VGND VPWR VPWR sky130_fd_sc_hd__decap_3
XFILLER_39_139 VGND VGND VPWR VPWR sky130_fd_sc_hd__decap_3
XFILLER_39_128 VGND VGND VPWR VPWR sky130_fd_sc_hd__decap_3
XFILLER_35_312 VGND VGND VPWR VPWR sky130_fd_sc_hd__decap_3
X_3070_ clknet_4_14_0_clk net107 _0166_ VGND VGND VPWR VPWR my_sum_sub.cm_exp\[0\]
+ sky130_fd_sc_hd__dfrtp_4
X_2021_ net76 _1099_ _0426_ _0427_ VGND VGND VPWR VPWR _0235_ sky130_fd_sc_hd__o22a_1
XFILLER_62_197 VGND VGND VPWR VPWR sky130_fd_sc_hd__decap_3
XFILLER_62_186 VGND VGND VPWR VPWR sky130_fd_sc_hd__decap_3
XFILLER_62_153 VGND VGND VPWR VPWR sky130_fd_sc_hd__decap_3
XFILLER_62_131 VGND VGND VPWR VPWR sky130_fd_sc_hd__decap_3
XFILLER_50_337 VGND VGND VPWR VPWR sky130_fd_sc_hd__fill_1
XFILLER_50_326 VGND VGND VPWR VPWR sky130_fd_sc_hd__decap_3
XFILLER_50_304 VGND VGND VPWR VPWR sky130_fd_sc_hd__decap_3
XFILLER_47_194 VGND VGND VPWR VPWR sky130_fd_sc_hd__decap_3
XFILLER_35_356 VGND VGND VPWR VPWR sky130_fd_sc_hd__decap_3
X_2923_ net5 VGND VGND VPWR VPWR _0019_ sky130_fd_sc_hd__inv_2
X_1805_ _1346_ _1347_ VGND VGND VPWR VPWR _1349_ sky130_fd_sc_hd__xnor2_1
X_1736_ _1276_ _1279_ _1275_ VGND VGND VPWR VPWR _1280_ sky130_fd_sc_hd__a21bo_1
Xhold202 my_sum_sub.al_ma\[7\] VGND VGND VPWR VPWR net207 sky130_fd_sc_hd__dlygate4sd3_1
Xhold213 _0308_ VGND VGND VPWR VPWR net218 sky130_fd_sc_hd__dlygate4sd3_1
X_2854_ net2 VGND VGND VPWR VPWR _0135_ sky130_fd_sc_hd__inv_2
X_2785_ net229 _0675_ _0973_ VGND VGND VPWR VPWR _0248_ sky130_fd_sc_hd__mux2_1
Xhold224 my_divider.divisor_reg\[0\] VGND VGND VPWR VPWR net229 sky130_fd_sc_hd__dlygate4sd3_1
Xhold235 _0197_ VGND VGND VPWR VPWR net240 sky130_fd_sc_hd__dlygate4sd3_1
X_1667_ my_mul.x2\[6\] acc_reg\[2\] acc_reg\[1\] VGND VGND VPWR VPWR _1211_ sky130_fd_sc_hd__and3_1
Xhold246 my_mul.x2\[4\] VGND VGND VPWR VPWR net251 sky130_fd_sc_hd__dlygate4sd3_1
Xhold268 my_sum_sub.al_ma\[0\] VGND VGND VPWR VPWR net273 sky130_fd_sc_hd__dlygate4sd3_1
Xhold257 my_mul.x2\[8\] VGND VGND VPWR VPWR net262 sky130_fd_sc_hd__dlygate4sd3_1
X_1598_ _1115_ _1138_ _1141_ _1114_ VGND VGND VPWR VPWR _1142_ sky130_fd_sc_hd__o31ai_1
Xhold279 state\[2\] VGND VGND VPWR VPWR net284 sky130_fd_sc_hd__dlygate4sd3_1
XFILLER_53_131 VGND VGND VPWR VPWR sky130_fd_sc_hd__decap_3
X_2219_ _1056_ _0553_ VGND VGND VPWR VPWR _0554_ sky130_fd_sc_hd__nor2_1
XFILLER_38_194 VGND VGND VPWR VPWR sky130_fd_sc_hd__fill_2
XFILLER_38_150 VGND VGND VPWR VPWR sky130_fd_sc_hd__decap_3
XTAP_TAPCELL_ROW_28_318 VGND VPWR sky130_fd_sc_hd__tapvpwrvgnd_1
XFILLER_41_359 VGND VGND VPWR VPWR sky130_fd_sc_hd__decap_3
XFILLER_41_326 VGND VGND VPWR VPWR sky130_fd_sc_hd__fill_1
XTAP_TAPCELL_ROW_11_207 VGND VPWR sky130_fd_sc_hd__tapvpwrvgnd_1
XFILLER_5_216 VGND VGND VPWR VPWR sky130_fd_sc_hd__decap_3
XFILLER_39_85 VGND VGND VPWR VPWR sky130_fd_sc_hd__decap_3
XFILLER_44_197 VGND VGND VPWR VPWR sky130_fd_sc_hd__decap_3
X_2570_ _0846_ _0867_ _0868_ VGND VGND VPWR VPWR _0869_ sky130_fd_sc_hd__a21oi_1
X_3122_ clknet_4_4_0_clk _0218_ _0033_ VGND VGND VPWR VPWR shift_in\[11\] sky130_fd_sc_hd__dfrtp_1
XFILLER_4_271 VGND VGND VPWR VPWR sky130_fd_sc_hd__decap_3
X_1521_ net173 _1067_ _1060_ VGND VGND VPWR VPWR _1071_ sky130_fd_sc_hd__o21a_1
X_3053_ clknet_4_15_0_clk net130 _0149_ VGND VGND VPWR VPWR my_sum_sub.al_mb\[4\]
+ sky130_fd_sc_hd__dfrtp_1
X_2004_ shift_out\[15\] _1064_ _1097_ acc_reg\[14\] _1100_ VGND VGND VPWR VPWR _0413_
+ sky130_fd_sc_hd__a221o_1
XFILLER_50_167 VGND VGND VPWR VPWR sky130_fd_sc_hd__decap_3
XFILLER_50_123 VGND VGND VPWR VPWR sky130_fd_sc_hd__decap_3
XFILLER_35_175 VGND VGND VPWR VPWR sky130_fd_sc_hd__decap_3
X_2906_ net5 VGND VGND VPWR VPWR _0187_ sky130_fd_sc_hd__inv_2
XFILLER_23_359 VGND VGND VPWR VPWR sky130_fd_sc_hd__decap_3
XFILLER_23_337 VGND VGND VPWR VPWR sky130_fd_sc_hd__fill_1
X_1719_ my_mul.x2\[6\] my_mul.x2\[5\] acc_reg\[1\] acc_reg\[0\] VGND VGND VPWR VPWR
+ _1263_ sky130_fd_sc_hd__nand4_1
X_2699_ my_divider.divisor_reg\[7\] my_divider.remainder_reg\[7\] VGND VGND VPWR VPWR
+ _0975_ sky130_fd_sc_hd__and2b_1
X_2768_ _1033_ VGND VGND VPWR VPWR _1034_ sky130_fd_sc_hd__inv_2
X_2837_ net2 VGND VGND VPWR VPWR _0118_ sky130_fd_sc_hd__inv_2
XFILLER_58_289 VGND VGND VPWR VPWR sky130_fd_sc_hd__decap_3
XFILLER_58_256 VGND VGND VPWR VPWR sky130_fd_sc_hd__decap_3
XFILLER_58_234 VGND VGND VPWR VPWR sky130_fd_sc_hd__fill_1
XFILLER_58_223 VGND VGND VPWR VPWR sky130_fd_sc_hd__fill_2
XFILLER_41_145 VGND VGND VPWR VPWR sky130_fd_sc_hd__fill_1
XFILLER_26_197 VGND VGND VPWR VPWR sky130_fd_sc_hd__decap_3
XFILLER_25_87 VGND VGND VPWR VPWR sky130_fd_sc_hd__decap_3
XFILLER_25_76 VGND VGND VPWR VPWR sky130_fd_sc_hd__fill_1
XFILLER_25_54 VGND VGND VPWR VPWR sky130_fd_sc_hd__fill_2
XFILLER_14_337 VGND VGND VPWR VPWR sky130_fd_sc_hd__fill_1
XFILLER_14_348 VGND VGND VPWR VPWR sky130_fd_sc_hd__fill_2
XFILLER_41_189 VGND VGND VPWR VPWR sky130_fd_sc_hd__decap_3
XFILLER_41_178 VGND VGND VPWR VPWR sky130_fd_sc_hd__decap_3
XFILLER_25_98 VGND VGND VPWR VPWR sky130_fd_sc_hd__decap_3
XFILLER_49_234 VGND VGND VPWR VPWR sky130_fd_sc_hd__decap_3
XFILLER_1_296 VGND VGND VPWR VPWR sky130_fd_sc_hd__decap_3
XTAP_TAPCELL_ROW_55_490 VGND VPWR sky130_fd_sc_hd__tapvpwrvgnd_1
XFILLER_20_307 VGND VGND VPWR VPWR sky130_fd_sc_hd__fill_1
X_2553_ my_sum_sub.cm_mant\[2\] _0730_ _0823_ my_sum_sub.cm_mant\[3\] _0851_ VGND
+ VGND VPWR VPWR _0852_ sky130_fd_sc_hd__o221a_2
X_2622_ my_sum_sub.cm_exp\[7\] _0908_ _0909_ _0920_ VGND VGND VPWR VPWR _0921_ sky130_fd_sc_hd__a2bb2o_1
X_1504_ net297 VGND VGND VPWR VPWR _1059_ sky130_fd_sc_hd__inv_2
XFILLER_55_215 VGND VGND VPWR VPWR sky130_fd_sc_hd__decap_3
X_3105_ clknet_4_4_0_clk _0201_ _0016_ VGND VGND VPWR VPWR my_mul.x2\[10\] sky130_fd_sc_hd__dfrtp_2
X_2484_ _0782_ VGND VGND VPWR VPWR _0783_ sky130_fd_sc_hd__inv_2
XFILLER_55_237 VGND VGND VPWR VPWR sky130_fd_sc_hd__decap_3
X_3036_ clknet_4_12_0_clk net99 _0132_ VGND VGND VPWR VPWR my_sum_sub.al_exp\[3\]
+ sky130_fd_sc_hd__dfrtp_1
XFILLER_11_12 VGND VGND VPWR VPWR sky130_fd_sc_hd__fill_1
Xclkbuf_4_2_0_clk clknet_0_clk VGND VGND VPWR VPWR clknet_4_2_0_clk sky130_fd_sc_hd__clkbuf_8
XFILLER_54_270 VGND VGND VPWR VPWR sky130_fd_sc_hd__decap_3
XTAP_TAPCELL_ROW_52_471 VGND VPWR sky130_fd_sc_hd__tapvpwrvgnd_1
XFILLER_36_75 VGND VGND VPWR VPWR sky130_fd_sc_hd__fill_1
XFILLER_14_189 VGND VGND VPWR VPWR sky130_fd_sc_hd__decap_3
XFILLER_52_96 VGND VGND VPWR VPWR sky130_fd_sc_hd__decap_3
XFILLER_10_362 VGND VGND VPWR VPWR sky130_fd_sc_hd__fill_2
XFILLER_28_6 VGND VGND VPWR VPWR sky130_fd_sc_hd__decap_3
XTAP_TAPCELL_ROW_9_193 VGND VPWR sky130_fd_sc_hd__tapvpwrvgnd_1
XFILLER_45_292 VGND VGND VPWR VPWR sky130_fd_sc_hd__fill_1
XFILLER_60_295 VGND VGND VPWR VPWR sky130_fd_sc_hd__decap_3
XFILLER_60_262 VGND VGND VPWR VPWR sky130_fd_sc_hd__decap_3
XFILLER_60_251 VGND VGND VPWR VPWR sky130_fd_sc_hd__fill_1
X_1984_ _0391_ _0392_ VGND VGND VPWR VPWR _0393_ sky130_fd_sc_hd__and2_1
X_2467_ _0762_ _0765_ VGND VGND VPWR VPWR _0766_ sky130_fd_sc_hd__nand2_1
X_2536_ _0833_ _0834_ VGND VGND VPWR VPWR _0835_ sky130_fd_sc_hd__or2_1
X_2605_ _0854_ _0903_ VGND VGND VPWR VPWR _0904_ sky130_fd_sc_hd__and2_1
XFILLER_43_207 VGND VGND VPWR VPWR sky130_fd_sc_hd__decap_3
X_2398_ net25 net20 VGND VGND VPWR VPWR _0697_ sky130_fd_sc_hd__nand2_1
XFILLER_51_240 VGND VGND VPWR VPWR sky130_fd_sc_hd__fill_1
X_3019_ clknet_4_8_0_clk _0278_ _0115_ VGND VGND VPWR VPWR my_sum_sub.result\[2\]
+ sky130_fd_sc_hd__dfrtp_1
XFILLER_7_108 VGND VGND VPWR VPWR sky130_fd_sc_hd__decap_3
XFILLER_59_340 VGND VGND VPWR VPWR sky130_fd_sc_hd__decap_3
XTAP_TAPCELL_ROW_6_174 VGND VPWR sky130_fd_sc_hd__tapvpwrvgnd_1
XFILLER_47_63 VGND VGND VPWR VPWR sky130_fd_sc_hd__fill_1
XFILLER_34_229 VGND VGND VPWR VPWR sky130_fd_sc_hd__decap_3
XFILLER_42_262 VGND VGND VPWR VPWR sky130_fd_sc_hd__fill_2
X_2321_ _0604_ _0637_ _0641_ _0619_ _1055_ VGND VGND VPWR VPWR _0642_ sky130_fd_sc_hd__a221o_1
X_2252_ _0546_ _0558_ _0581_ _0582_ VGND VGND VPWR VPWR _0583_ sky130_fd_sc_hd__a2bb2o_1
X_2183_ net213 net154 VGND VGND VPWR VPWR _0518_ sky130_fd_sc_hd__nand2b_1
XFILLER_33_240 VGND VGND VPWR VPWR sky130_fd_sc_hd__decap_3
XFILLER_25_207 VGND VGND VPWR VPWR sky130_fd_sc_hd__decap_3
X_1898_ _1132_ _1135_ _1123_ VGND VGND VPWR VPWR _1442_ sky130_fd_sc_hd__o21ai_1
X_1967_ _1427_ _1437_ VGND VGND VPWR VPWR _0376_ sky130_fd_sc_hd__or2_1
X_2519_ _0795_ _0799_ _0805_ _0817_ VGND VGND VPWR VPWR _0818_ sky130_fd_sc_hd__o211ai_1
XFILLER_56_365 VGND VGND VPWR VPWR sky130_fd_sc_hd__decap_3
XTAP_TAPCELL_ROW_3_155 VGND VPWR sky130_fd_sc_hd__tapvpwrvgnd_1
XFILLER_17_55 VGND VGND VPWR VPWR sky130_fd_sc_hd__fill_1
XFILLER_3_111 VGND VGND VPWR VPWR sky130_fd_sc_hd__fill_1
XFILLER_59_181 VGND VGND VPWR VPWR sky130_fd_sc_hd__decap_3
XFILLER_62_368 VGND VGND VPWR VPWR sky130_fd_sc_hd__fill_2
XFILLER_62_346 VGND VGND VPWR VPWR sky130_fd_sc_hd__decap_3
XFILLER_62_324 VGND VGND VPWR VPWR sky130_fd_sc_hd__decap_3
XFILLER_62_302 VGND VGND VPWR VPWR sky130_fd_sc_hd__decap_3
XTAP_TAPCELL_ROW_60_525 VGND VPWR sky130_fd_sc_hd__tapvpwrvgnd_1
X_2870_ net2 VGND VGND VPWR VPWR _0151_ sky130_fd_sc_hd__inv_2
XTAP_TAPCELL_ROW_17_246 VGND VPWR sky130_fd_sc_hd__tapvpwrvgnd_1
X_1752_ _1263_ _1295_ VGND VGND VPWR VPWR _1296_ sky130_fd_sc_hd__nand2_1
X_1821_ my_mul.x2\[1\] acc_reg\[3\] VGND VGND VPWR VPWR _1365_ sky130_fd_sc_hd__nand2_1
X_1683_ _1185_ _1205_ VGND VGND VPWR VPWR _1227_ sky130_fd_sc_hd__nand2b_1
X_2304_ my_sum_sub.state\[2\] net134 _0626_ VGND VGND VPWR VPWR _0315_ sky130_fd_sc_hd__o21a_1
XFILLER_53_346 VGND VGND VPWR VPWR sky130_fd_sc_hd__decap_3
XFILLER_53_324 VGND VGND VPWR VPWR sky130_fd_sc_hd__decap_3
X_2235_ my_sum_sub.al_b_larger _0513_ _0568_ VGND VGND VPWR VPWR _0569_ sky130_fd_sc_hd__or3_1
X_2097_ net49 _1099_ _0491_ _0492_ VGND VGND VPWR VPWR _0224_ sky130_fd_sc_hd__o22a_1
XFILLER_38_343 VGND VGND VPWR VPWR sky130_fd_sc_hd__decap_3
X_2166_ my_sum_sub.cm_exp\[5\] net117 my_sum_sub.state\[1\] VGND VGND VPWR VPWR _0334_
+ sky130_fd_sc_hd__mux2_1
XTAP_TAPCELL_ROW_0_136 VGND VPWR sky130_fd_sc_hd__tapvpwrvgnd_1
XPHY_EDGE_ROW_3_Right_3 VGND VGND VPWR VPWR sky130_fd_sc_hd__decap_3
X_2999_ clknet_4_0_0_clk net109 _0095_ VGND VGND VPWR VPWR my_divider.counter\[2\]
+ sky130_fd_sc_hd__dfrtp_1
XFILLER_0_125 VGND VGND VPWR VPWR sky130_fd_sc_hd__decap_3
XFILLER_0_147 VGND VGND VPWR VPWR sky130_fd_sc_hd__fill_1
XFILLER_0_169 VGND VGND VPWR VPWR sky130_fd_sc_hd__decap_3
XFILLER_56_151 VGND VGND VPWR VPWR sky130_fd_sc_hd__decap_3
XFILLER_44_368 VGND VGND VPWR VPWR sky130_fd_sc_hd__fill_2
XTAP_TAPCELL_ROW_14_227 VGND VPWR sky130_fd_sc_hd__tapvpwrvgnd_1
XFILLER_60_52 VGND VGND VPWR VPWR sky130_fd_sc_hd__decap_3
XFILLER_44_97 VGND VGND VPWR VPWR sky130_fd_sc_hd__fill_1
XFILLER_8_236 VGND VGND VPWR VPWR sky130_fd_sc_hd__fill_1
XFILLER_8_269 VGND VGND VPWR VPWR sky130_fd_sc_hd__decap_3
XFILLER_12_265 VGND VGND VPWR VPWR sky130_fd_sc_hd__fill_2
XFILLER_12_287 VGND VGND VPWR VPWR sky130_fd_sc_hd__decap_3
XFILLER_5_36 VGND VGND VPWR VPWR sky130_fd_sc_hd__fill_1
XFILLER_35_324 VGND VGND VPWR VPWR sky130_fd_sc_hd__decap_3
X_2020_ net64 _1064_ _1097_ acc_reg\[12\] _1100_ VGND VGND VPWR VPWR _0427_ sky130_fd_sc_hd__a221o_1
XFILLER_10_6 VGND VGND VPWR VPWR sky130_fd_sc_hd__decap_3
XFILLER_62_165 VGND VGND VPWR VPWR sky130_fd_sc_hd__decap_3
X_2922_ net5 VGND VGND VPWR VPWR _0018_ sky130_fd_sc_hd__inv_2
X_2853_ net2 VGND VGND VPWR VPWR _0134_ sky130_fd_sc_hd__inv_2
X_1666_ _1191_ _1193_ VGND VGND VPWR VPWR _1210_ sky130_fd_sc_hd__xnor2_1
X_1804_ my_mul.x2\[1\] acc_reg\[4\] _1346_ VGND VGND VPWR VPWR _1348_ sky130_fd_sc_hd__and3_1
X_1735_ _1277_ _1278_ VGND VGND VPWR VPWR _1279_ sky130_fd_sc_hd__and2_1
Xhold203 _0307_ VGND VGND VPWR VPWR net208 sky130_fd_sc_hd__dlygate4sd3_1
Xhold269 my_sum_sub.cm_mant\[5\] VGND VGND VPWR VPWR net274 sky130_fd_sc_hd__dlygate4sd3_1
Xhold258 _0293_ VGND VGND VPWR VPWR net263 sky130_fd_sc_hd__dlygate4sd3_1
Xhold247 my_mul.x2\[9\] VGND VGND VPWR VPWR net252 sky130_fd_sc_hd__dlygate4sd3_1
Xhold214 my_divider.counter\[1\] VGND VGND VPWR VPWR net219 sky130_fd_sc_hd__dlygate4sd3_1
X_2784_ net79 _0668_ _0973_ VGND VGND VPWR VPWR _0249_ sky130_fd_sc_hd__mux2_1
Xhold225 _0248_ VGND VGND VPWR VPWR net230 sky130_fd_sc_hd__dlygate4sd3_1
Xhold236 op_reg\[2\] VGND VGND VPWR VPWR net241 sky130_fd_sc_hd__dlygate4sd3_1
X_1597_ _1136_ _1140_ VGND VGND VPWR VPWR _1141_ sky130_fd_sc_hd__nor2_1
XFILLER_53_176 VGND VGND VPWR VPWR sky130_fd_sc_hd__decap_3
XFILLER_53_154 VGND VGND VPWR VPWR sky130_fd_sc_hd__decap_3
XFILLER_38_162 VGND VGND VPWR VPWR sky130_fd_sc_hd__decap_3
X_2218_ my_sum_sub.al_ma\[0\] _0524_ VGND VGND VPWR VPWR _0553_ sky130_fd_sc_hd__nand2_1
XTAP_TAPCELL_ROW_28_319 VGND VPWR sky130_fd_sc_hd__tapvpwrvgnd_1
X_2149_ net271 _0504_ _0506_ _0426_ VGND VGND VPWR VPWR _0350_ sky130_fd_sc_hd__o22a_1
XTAP_TAPCELL_ROW_11_208 VGND VPWR sky130_fd_sc_hd__tapvpwrvgnd_1
XFILLER_30_88 VGND VGND VPWR VPWR sky130_fd_sc_hd__fill_1
XFILLER_55_41 VGND VGND VPWR VPWR sky130_fd_sc_hd__decap_3
XFILLER_55_85 VGND VGND VPWR VPWR sky130_fd_sc_hd__decap_3
XFILLER_17_368 VGND VGND VPWR VPWR sky130_fd_sc_hd__fill_2
XFILLER_58_6 VGND VGND VPWR VPWR sky130_fd_sc_hd__decap_3
X_1520_ _1069_ VGND VGND VPWR VPWR _1070_ sky130_fd_sc_hd__inv_2
X_3121_ clknet_4_4_0_clk _0217_ _0032_ VGND VGND VPWR VPWR shift_in\[10\] sky130_fd_sc_hd__dfrtp_1
XFILLER_4_283 VGND VGND VPWR VPWR sky130_fd_sc_hd__decap_3
X_3052_ clknet_4_13_0_clk net155 _0148_ VGND VGND VPWR VPWR my_sum_sub.al_mb\[3\]
+ sky130_fd_sc_hd__dfrtp_1
XFILLER_35_187 VGND VGND VPWR VPWR sky130_fd_sc_hd__fill_1
XFILLER_35_121 VGND VGND VPWR VPWR sky130_fd_sc_hd__decap_3
X_2003_ net125 _1091_ _0382_ _0411_ state\[4\] VGND VGND VPWR VPWR _0412_ sky130_fd_sc_hd__o221a_1
XFILLER_50_179 VGND VGND VPWR VPWR sky130_fd_sc_hd__decap_3
XFILLER_50_135 VGND VGND VPWR VPWR sky130_fd_sc_hd__decap_3
X_2905_ net5 VGND VGND VPWR VPWR _0186_ sky130_fd_sc_hd__inv_2
X_2836_ net2 VGND VGND VPWR VPWR _0117_ sky130_fd_sc_hd__inv_2
X_1718_ my_mul.x2\[5\] acc_reg\[0\] VGND VGND VPWR VPWR _1262_ sky130_fd_sc_hd__nand2_1
X_1649_ _1190_ _1192_ VGND VGND VPWR VPWR _1193_ sky130_fd_sc_hd__and2b_1
X_2767_ net219 my_divider.counter\[0\] net168 VGND VGND VPWR VPWR _1033_ sky130_fd_sc_hd__and3_1
XFILLER_2_209 VGND VGND VPWR VPWR sky130_fd_sc_hd__decap_3
X_2698_ div_quotient\[0\] _0972_ _0974_ net163 VGND VGND VPWR VPWR _0270_ sky130_fd_sc_hd__a22o_1
XFILLER_58_268 VGND VGND VPWR VPWR sky130_fd_sc_hd__decap_3
XFILLER_26_187 VGND VGND VPWR VPWR sky130_fd_sc_hd__decap_3
XFILLER_26_176 VGND VGND VPWR VPWR sky130_fd_sc_hd__fill_1
XTAP_TAPCELL_ROW_55_491 VGND VPWR sky130_fd_sc_hd__tapvpwrvgnd_1
XFILLER_20_319 VGND VGND VPWR VPWR sky130_fd_sc_hd__fill_2
XFILLER_56_3 VGND VGND VPWR VPWR sky130_fd_sc_hd__decap_3
X_2552_ my_sum_sub.cm_mant\[4\] net8 VGND VGND VPWR VPWR _0851_ sky130_fd_sc_hd__nand2b_1
X_1503_ net214 VGND VGND VPWR VPWR _1058_ sky130_fd_sc_hd__inv_2
X_2483_ _0780_ _0781_ VGND VGND VPWR VPWR _0782_ sky130_fd_sc_hd__or2_1
X_2621_ _0876_ _0879_ _0905_ _0878_ VGND VGND VPWR VPWR _0920_ sky130_fd_sc_hd__a31o_1
XFILLER_55_249 VGND VGND VPWR VPWR sky130_fd_sc_hd__decap_3
X_3035_ clknet_4_12_0_clk net253 _0131_ VGND VGND VPWR VPWR my_sum_sub.al_exp\[2\]
+ sky130_fd_sc_hd__dfrtp_1
X_3104_ clknet_4_5_0_clk net82 _0015_ VGND VGND VPWR VPWR my_mul.x2\[9\] sky130_fd_sc_hd__dfrtp_2
XPHY_EDGE_ROW_43_Left_106 VGND VGND VPWR VPWR sky130_fd_sc_hd__decap_3
XFILLER_11_308 VGND VGND VPWR VPWR sky130_fd_sc_hd__decap_3
XPHY_EDGE_ROW_52_Left_115 VGND VGND VPWR VPWR sky130_fd_sc_hd__decap_3
X_2819_ net2 VGND VGND VPWR VPWR _0100_ sky130_fd_sc_hd__inv_2
XFILLER_61_219 VGND VGND VPWR VPWR sky130_fd_sc_hd__decap_3
XPHY_EDGE_ROW_61_Left_124 VGND VGND VPWR VPWR sky130_fd_sc_hd__decap_3
XFILLER_46_205 VGND VGND VPWR VPWR sky130_fd_sc_hd__fill_2
XFILLER_36_21 VGND VGND VPWR VPWR sky130_fd_sc_hd__decap_3
XFILLER_54_282 VGND VGND VPWR VPWR sky130_fd_sc_hd__decap_3
XTAP_TAPCELL_ROW_52_472 VGND VPWR sky130_fd_sc_hd__tapvpwrvgnd_1
XFILLER_52_20 VGND VGND VPWR VPWR sky130_fd_sc_hd__decap_3
XFILLER_10_341 VGND VGND VPWR VPWR sky130_fd_sc_hd__fill_2
XFILLER_10_352 VGND VGND VPWR VPWR sky130_fd_sc_hd__decap_3
XFILLER_14_135 VGND VGND VPWR VPWR sky130_fd_sc_hd__decap_3
XFILLER_14_179 VGND VGND VPWR VPWR sky130_fd_sc_hd__fill_2
XFILLER_6_312 VGND VGND VPWR VPWR sky130_fd_sc_hd__decap_3
XFILLER_6_334 VGND VGND VPWR VPWR sky130_fd_sc_hd__decap_3
XTAP_TAPCELL_ROW_9_194 VGND VPWR sky130_fd_sc_hd__tapvpwrvgnd_1
XFILLER_60_274 VGND VGND VPWR VPWR sky130_fd_sc_hd__decap_3
XFILLER_45_260 VGND VGND VPWR VPWR sky130_fd_sc_hd__decap_3
XFILLER_37_249 VGND VGND VPWR VPWR sky130_fd_sc_hd__decap_3
X_1983_ _1051_ acc_reg\[11\] _1112_ VGND VGND VPWR VPWR _0392_ sky130_fd_sc_hd__a21bo_1
XFILLER_9_172 VGND VGND VPWR VPWR sky130_fd_sc_hd__decap_3
X_2604_ _0827_ _0896_ _0901_ _0902_ VGND VGND VPWR VPWR _0903_ sky130_fd_sc_hd__a22o_1
X_2535_ _0779_ _0803_ _0786_ VGND VGND VPWR VPWR _0834_ sky130_fd_sc_hd__a21bo_1
X_2466_ _0740_ _0764_ VGND VGND VPWR VPWR _0765_ sky130_fd_sc_hd__nand2_2
XTAP_TAPCELL_ROW_58_509 VGND VPWR sky130_fd_sc_hd__tapvpwrvgnd_1
XFILLER_43_219 VGND VGND VPWR VPWR sky130_fd_sc_hd__decap_3
XFILLER_36_260 VGND VGND VPWR VPWR sky130_fd_sc_hd__fill_1
X_2397_ net106 _1055_ _0607_ net110 _0696_ VGND VGND VPWR VPWR _0292_ sky130_fd_sc_hd__a221o_1
XFILLER_28_227 VGND VGND VPWR VPWR sky130_fd_sc_hd__decap_3
X_3018_ clknet_4_10_0_clk _0277_ _0114_ VGND VGND VPWR VPWR my_sum_sub.result\[1\]
+ sky130_fd_sc_hd__dfrtp_1
XFILLER_3_326 VGND VGND VPWR VPWR sky130_fd_sc_hd__decap_3
XFILLER_3_304 VGND VGND VPWR VPWR sky130_fd_sc_hd__fill_1
XPHY_EDGE_ROW_5_Left_68 VGND VGND VPWR VPWR sky130_fd_sc_hd__decap_3
XFILLER_59_352 VGND VGND VPWR VPWR sky130_fd_sc_hd__decap_3
XFILLER_47_31 VGND VGND VPWR VPWR sky130_fd_sc_hd__decap_3
XTAP_TAPCELL_ROW_6_175 VGND VPWR sky130_fd_sc_hd__tapvpwrvgnd_1
XFILLER_47_97 VGND VGND VPWR VPWR sky130_fd_sc_hd__decap_3
XFILLER_42_241 VGND VGND VPWR VPWR sky130_fd_sc_hd__decap_3
XFILLER_6_153 VGND VGND VPWR VPWR sky130_fd_sc_hd__fill_1
XFILLER_8_14 VGND VGND VPWR VPWR sky130_fd_sc_hd__decap_3
XFILLER_10_193 VGND VGND VPWR VPWR sky130_fd_sc_hd__decap_3
X_2251_ my_sum_sub.al_b_larger _0539_ _0546_ VGND VGND VPWR VPWR _0582_ sky130_fd_sc_hd__o21a_1
X_2320_ _1153_ _0624_ _0629_ _0640_ VGND VGND VPWR VPWR _0641_ sky130_fd_sc_hd__a31o_1
X_2182_ net154 net213 VGND VGND VPWR VPWR _0517_ sky130_fd_sc_hd__nand2b_1
XFILLER_25_219 VGND VGND VPWR VPWR sky130_fd_sc_hd__decap_3
Xclkbuf_4_1_0_clk clknet_0_clk VGND VGND VPWR VPWR clknet_4_1_0_clk sky130_fd_sc_hd__clkbuf_8
XFILLER_19_3 VGND VGND VPWR VPWR sky130_fd_sc_hd__decap_3
X_1966_ _1427_ _1437_ VGND VGND VPWR VPWR _0375_ sky130_fd_sc_hd__nand2_1
X_1897_ _1426_ _1440_ VGND VGND VPWR VPWR _1441_ sky130_fd_sc_hd__or2_1
X_2449_ _0744_ _0736_ _0739_ _0708_ VGND VGND VPWR VPWR _0748_ sky130_fd_sc_hd__nor4_4
X_2518_ _0816_ VGND VGND VPWR VPWR _0817_ sky130_fd_sc_hd__inv_2
XFILLER_0_318 VGND VGND VPWR VPWR sky130_fd_sc_hd__decap_3
XFILLER_24_241 VGND VGND VPWR VPWR sky130_fd_sc_hd__decap_3
XTAP_TAPCELL_ROW_3_156 VGND VPWR sky130_fd_sc_hd__tapvpwrvgnd_1
XFILLER_3_167 VGND VGND VPWR VPWR sky130_fd_sc_hd__fill_1
XFILLER_3_156 VGND VGND VPWR VPWR sky130_fd_sc_hd__decap_3
XFILLER_59_193 VGND VGND VPWR VPWR sky130_fd_sc_hd__decap_3
XFILLER_59_160 VGND VGND VPWR VPWR sky130_fd_sc_hd__decap_3
XFILLER_58_85 VGND VGND VPWR VPWR sky130_fd_sc_hd__decap_3
XFILLER_58_63 VGND VGND VPWR VPWR sky130_fd_sc_hd__decap_3
XFILLER_47_322 VGND VGND VPWR VPWR sky130_fd_sc_hd__decap_3
XFILLER_62_358 VGND VGND VPWR VPWR sky130_fd_sc_hd__decap_3
XTAP_TAPCELL_ROW_60_526 VGND VPWR sky130_fd_sc_hd__tapvpwrvgnd_1
X_1820_ my_mul.x2\[3\] my_mul.x2\[2\] acc_reg\[1\] acc_reg\[0\] VGND VGND VPWR VPWR
+ _1364_ sky130_fd_sc_hd__and4_1
XFILLER_30_222 VGND VGND VPWR VPWR sky130_fd_sc_hd__decap_3
XFILLER_30_200 VGND VGND VPWR VPWR sky130_fd_sc_hd__decap_3
XFILLER_15_274 VGND VGND VPWR VPWR sky130_fd_sc_hd__decap_3
XTAP_TAPCELL_ROW_17_247 VGND VPWR sky130_fd_sc_hd__tapvpwrvgnd_1
X_1751_ my_mul.x2\[5\] acc_reg\[1\] acc_reg\[0\] my_mul.x2\[6\] VGND VGND VPWR VPWR
+ _1295_ sky130_fd_sc_hd__a22o_1
X_1682_ _1222_ _1225_ _1207_ VGND VGND VPWR VPWR _1226_ sky130_fd_sc_hd__a21o_1
XFILLER_57_119 VGND VGND VPWR VPWR sky130_fd_sc_hd__decap_3
X_2234_ _0514_ _0567_ VGND VGND VPWR VPWR _0568_ sky130_fd_sc_hd__nor2_1
X_2303_ _0619_ _0625_ _0606_ VGND VGND VPWR VPWR _0626_ sky130_fd_sc_hd__a21bo_1
XFILLER_53_358 VGND VGND VPWR VPWR sky130_fd_sc_hd__fill_1
X_2096_ net46 _1064_ _1097_ acc_reg\[1\] _1100_ VGND VGND VPWR VPWR _0492_ sky130_fd_sc_hd__a221o_1
X_2165_ my_sum_sub.cm_exp\[6\] net119 my_sum_sub.state\[1\] VGND VGND VPWR VPWR _0335_
+ sky130_fd_sc_hd__mux2_1
XTAP_TAPCELL_ROW_0_137 VGND VPWR sky130_fd_sc_hd__tapvpwrvgnd_1
XTAP_TAPCELL_ROW_0_126 VGND VPWR sky130_fd_sc_hd__tapvpwrvgnd_1
XFILLER_0_70 VGND VGND VPWR VPWR sky130_fd_sc_hd__decap_3
X_1949_ my_mul.x2\[15\] my_mul.x2\[8\] _1491_ _1492_ VGND VGND VPWR VPWR _1493_ sky130_fd_sc_hd__or4_1
X_2998_ clknet_4_0_0_clk net220 _0094_ VGND VGND VPWR VPWR my_divider.counter\[1\]
+ sky130_fd_sc_hd__dfrtp_1
XFILLER_0_137 VGND VGND VPWR VPWR sky130_fd_sc_hd__decap_3
XFILLER_56_185 VGND VGND VPWR VPWR sky130_fd_sc_hd__fill_2
XFILLER_44_32 VGND VGND VPWR VPWR sky130_fd_sc_hd__decap_3
XTAP_TAPCELL_ROW_14_228 VGND VPWR sky130_fd_sc_hd__tapvpwrvgnd_1
XFILLER_60_64 VGND VGND VPWR VPWR sky130_fd_sc_hd__fill_1
XFILLER_8_215 VGND VGND VPWR VPWR sky130_fd_sc_hd__fill_1
XFILLER_8_259 VGND VGND VPWR VPWR sky130_fd_sc_hd__decap_3
XFILLER_12_299 VGND VGND VPWR VPWR sky130_fd_sc_hd__decap_3
XPHY_EDGE_ROW_8_Left_71 VGND VGND VPWR VPWR sky130_fd_sc_hd__decap_3
XFILLER_62_144 VGND VGND VPWR VPWR sky130_fd_sc_hd__decap_3
XFILLER_62_122 VGND VGND VPWR VPWR sky130_fd_sc_hd__decap_3
XFILLER_62_100 VGND VGND VPWR VPWR sky130_fd_sc_hd__decap_3
XFILLER_47_185 VGND VGND VPWR VPWR sky130_fd_sc_hd__decap_3
XFILLER_47_163 VGND VGND VPWR VPWR sky130_fd_sc_hd__decap_3
XFILLER_47_141 VGND VGND VPWR VPWR sky130_fd_sc_hd__decap_3
XFILLER_35_347 VGND VGND VPWR VPWR sky130_fd_sc_hd__decap_3
XPHY_EDGE_ROW_13_Right_13 VGND VGND VPWR VPWR sky130_fd_sc_hd__decap_3
XFILLER_62_177 VGND VGND VPWR VPWR sky130_fd_sc_hd__decap_3
X_1803_ my_mul.x2\[1\] acc_reg\[4\] VGND VGND VPWR VPWR _1347_ sky130_fd_sc_hd__nand2_1
XFILLER_50_317 VGND VGND VPWR VPWR sky130_fd_sc_hd__decap_3
X_2921_ net2 VGND VGND VPWR VPWR _0017_ sky130_fd_sc_hd__inv_2
X_2852_ net2 VGND VGND VPWR VPWR _0133_ sky130_fd_sc_hd__inv_2
XPHY_EDGE_ROW_22_Right_22 VGND VGND VPWR VPWR sky130_fd_sc_hd__decap_3
X_2783_ net70 _0659_ _0973_ VGND VGND VPWR VPWR _0250_ sky130_fd_sc_hd__mux2_1
X_1734_ my_mul.x2\[1\] _1265_ _1269_ VGND VGND VPWR VPWR _1278_ sky130_fd_sc_hd__or3_1
X_1665_ _1200_ _1208_ VGND VGND VPWR VPWR _1209_ sky130_fd_sc_hd__and2_1
Xhold204 my_sum_sub.al_ma\[4\] VGND VGND VPWR VPWR net209 sky130_fd_sc_hd__dlygate4sd3_1
Xhold259 my_sum_sub.cm_mant\[4\] VGND VGND VPWR VPWR net264 sky130_fd_sc_hd__dlygate4sd3_1
Xhold248 _0294_ VGND VGND VPWR VPWR net253 sky130_fd_sc_hd__dlygate4sd3_1
X_1596_ _1138_ _1139_ VGND VGND VPWR VPWR _1140_ sky130_fd_sc_hd__or2_1
Xhold226 op_reg\[0\] VGND VGND VPWR VPWR net231 sky130_fd_sc_hd__dlygate4sd3_1
Xhold215 _0257_ VGND VGND VPWR VPWR net220 sky130_fd_sc_hd__dlygate4sd3_1
Xhold237 _0246_ VGND VGND VPWR VPWR net242 sky130_fd_sc_hd__dlygate4sd3_1
X_2217_ my_sum_sub.al_mb\[2\] my_sum_sub.al_ma\[2\] VGND VGND VPWR VPWR _0552_ sky130_fd_sc_hd__nand2_1
XFILLER_38_141 VGND VGND VPWR VPWR sky130_fd_sc_hd__decap_3
XPHY_EDGE_ROW_31_Right_31 VGND VGND VPWR VPWR sky130_fd_sc_hd__decap_3
XFILLER_53_166 VGND VGND VPWR VPWR sky130_fd_sc_hd__fill_2
XFILLER_53_122 VGND VGND VPWR VPWR sky130_fd_sc_hd__decap_3
XFILLER_53_111 VGND VGND VPWR VPWR sky130_fd_sc_hd__fill_1
X_2079_ net44 _1099_ _0476_ _0477_ VGND VGND VPWR VPWR _0227_ sky130_fd_sc_hd__o22a_1
XFILLER_38_185 VGND VGND VPWR VPWR sky130_fd_sc_hd__decap_3
X_2148_ net258 _0504_ _0506_ _0418_ VGND VGND VPWR VPWR _0351_ sky130_fd_sc_hd__o22a_1
XPHY_EDGE_ROW_40_Right_40 VGND VGND VPWR VPWR sky130_fd_sc_hd__decap_3
XFILLER_30_23 VGND VGND VPWR VPWR sky130_fd_sc_hd__decap_3
XTAP_TAPCELL_ROW_11_209 VGND VPWR sky130_fd_sc_hd__tapvpwrvgnd_1
XFILLER_55_53 VGND VGND VPWR VPWR sky130_fd_sc_hd__decap_3
XFILLER_44_155 VGND VGND VPWR VPWR sky130_fd_sc_hd__decap_3
XPHY_EDGE_ROW_34_Left_97 VGND VGND VPWR VPWR sky130_fd_sc_hd__decap_3
XFILLER_17_314 VGND VGND VPWR VPWR sky130_fd_sc_hd__decap_3
XFILLER_44_177 VGND VGND VPWR VPWR sky130_fd_sc_hd__decap_3
X_3051_ clknet_4_13_0_clk net141 _0147_ VGND VGND VPWR VPWR my_sum_sub.al_mb\[2\]
+ sky130_fd_sc_hd__dfrtp_1
X_3120_ clknet_4_4_0_clk net84 _0031_ VGND VGND VPWR VPWR shift_in\[9\] sky130_fd_sc_hd__dfrtp_1
XFILLER_4_295 VGND VGND VPWR VPWR sky130_fd_sc_hd__decap_3
XFILLER_35_166 VGND VGND VPWR VPWR sky130_fd_sc_hd__fill_2
XFILLER_35_111 VGND VGND VPWR VPWR sky130_fd_sc_hd__fill_1
X_2002_ _1088_ _0407_ _0410_ _1090_ VGND VGND VPWR VPWR _0411_ sky130_fd_sc_hd__a31o_1
X_2904_ net5 VGND VGND VPWR VPWR _0185_ sky130_fd_sc_hd__inv_2
X_2766_ _0676_ _0973_ _0974_ net214 VGND VGND VPWR VPWR _0260_ sky130_fd_sc_hd__a22o_1
X_2835_ net2 VGND VGND VPWR VPWR _0116_ sky130_fd_sc_hd__inv_2
X_1648_ my_mul.x2\[6\] acc_reg\[3\] acc_reg\[2\] VGND VGND VPWR VPWR _1192_ sky130_fd_sc_hd__a21o_1
XFILLER_58_214 VGND VGND VPWR VPWR sky130_fd_sc_hd__decap_3
XFILLER_58_203 VGND VGND VPWR VPWR sky130_fd_sc_hd__fill_2
X_1717_ _1242_ _1247_ VGND VGND VPWR VPWR _1261_ sky130_fd_sc_hd__xor2_1
X_1579_ _1120_ _1122_ VGND VGND VPWR VPWR _1123_ sky130_fd_sc_hd__or2_1
X_2697_ net163 _0972_ _0974_ net115 VGND VGND VPWR VPWR _0271_ sky130_fd_sc_hd__a22o_1
XFILLER_58_247 VGND VGND VPWR VPWR sky130_fd_sc_hd__decap_3
XFILLER_41_158 VGND VGND VPWR VPWR sky130_fd_sc_hd__fill_1
XFILLER_14_306 VGND VGND VPWR VPWR sky130_fd_sc_hd__fill_2
XFILLER_14_328 VGND VGND VPWR VPWR sky130_fd_sc_hd__decap_3
XFILLER_1_210 VGND VGND VPWR VPWR sky130_fd_sc_hd__decap_3
XFILLER_49_225 VGND VGND VPWR VPWR sky130_fd_sc_hd__decap_3
XFILLER_1_287 VGND VGND VPWR VPWR sky130_fd_sc_hd__decap_3
XTAP_TAPCELL_ROW_55_492 VGND VPWR sky130_fd_sc_hd__tapvpwrvgnd_1
XFILLER_9_310 VGND VGND VPWR VPWR sky130_fd_sc_hd__decap_3
XFILLER_9_332 VGND VGND VPWR VPWR sky130_fd_sc_hd__decap_3
X_2620_ _0876_ _0877_ _0879_ _0905_ VGND VGND VPWR VPWR _0919_ sky130_fd_sc_hd__and4_1
XFILLER_49_3 VGND VGND VPWR VPWR sky130_fd_sc_hd__decap_3
X_2551_ _0836_ _0842_ _0843_ _0849_ VGND VGND VPWR VPWR _0850_ sky130_fd_sc_hd__or4b_4
X_2482_ _0720_ _0748_ _0779_ VGND VGND VPWR VPWR _0781_ sky130_fd_sc_hd__a21oi_1
X_1502_ net133 VGND VGND VPWR VPWR _1057_ sky130_fd_sc_hd__clkinv_4
XFILLER_55_228 VGND VGND VPWR VPWR sky130_fd_sc_hd__decap_3
XFILLER_55_206 VGND VGND VPWR VPWR sky130_fd_sc_hd__decap_3
X_3034_ clknet_4_14_0_clk net263 _0130_ VGND VGND VPWR VPWR my_sum_sub.al_exp\[1\]
+ sky130_fd_sc_hd__dfrtp_1
X_3103_ clknet_4_7_0_clk net69 _0014_ VGND VGND VPWR VPWR my_mul.x2\[8\] sky130_fd_sc_hd__dfrtp_4
XFILLER_23_158 VGND VGND VPWR VPWR sky130_fd_sc_hd__fill_1
XFILLER_31_180 VGND VGND VPWR VPWR sky130_fd_sc_hd__decap_3
X_2749_ net194 _1019_ _1002_ VGND VGND VPWR VPWR _1020_ sky130_fd_sc_hd__mux2_1
X_2818_ net2 VGND VGND VPWR VPWR _0099_ sky130_fd_sc_hd__inv_2
XFILLER_11_47 VGND VGND VPWR VPWR sky130_fd_sc_hd__decap_3
XFILLER_2_9 VGND VGND VPWR VPWR sky130_fd_sc_hd__decap_3
XFILLER_54_250 VGND VGND VPWR VPWR sky130_fd_sc_hd__fill_2
XTAP_TAPCELL_ROW_44_418 VGND VPWR sky130_fd_sc_hd__tapvpwrvgnd_1
XTAP_TAPCELL_ROW_52_473 VGND VPWR sky130_fd_sc_hd__tapvpwrvgnd_1
XFILLER_52_65 VGND VGND VPWR VPWR sky130_fd_sc_hd__decap_3
XFILLER_6_324 VGND VGND VPWR VPWR sky130_fd_sc_hd__fill_1
XFILLER_10_320 VGND VGND VPWR VPWR sky130_fd_sc_hd__decap_3
XFILLER_35_9 VGND VGND VPWR VPWR sky130_fd_sc_hd__fill_1
XFILLER_6_346 VGND VGND VPWR VPWR sky130_fd_sc_hd__decap_3
XFILLER_6_368 VGND VGND VPWR VPWR sky130_fd_sc_hd__fill_2
XFILLER_37_228 VGND VGND VPWR VPWR sky130_fd_sc_hd__decap_3
XFILLER_37_206 VGND VGND VPWR VPWR sky130_fd_sc_hd__decap_3
XTAP_TAPCELL_ROW_9_195 VGND VPWR sky130_fd_sc_hd__tapvpwrvgnd_1
XFILLER_60_286 VGND VGND VPWR VPWR sky130_fd_sc_hd__decap_3
XFILLER_60_253 VGND VGND VPWR VPWR sky130_fd_sc_hd__decap_3
XFILLER_60_220 VGND VGND VPWR VPWR sky130_fd_sc_hd__decap_3
X_1982_ _1112_ my_mul.x2\[11\] acc_reg\[11\] VGND VGND VPWR VPWR _0391_ sky130_fd_sc_hd__or3b_1
XFILLER_20_128 VGND VGND VPWR VPWR sky130_fd_sc_hd__decap_3
XPHY_EDGE_ROW_21_Left_84 VGND VGND VPWR VPWR sky130_fd_sc_hd__decap_3
X_2534_ _0800_ _0802_ _0832_ VGND VGND VPWR VPWR _0833_ sky130_fd_sc_hd__nor3b_1
X_2603_ _0770_ _0826_ _0798_ VGND VGND VPWR VPWR _0902_ sky130_fd_sc_hd__o21ai_1
X_2396_ acc_reg\[7\] _0606_ VGND VGND VPWR VPWR _0696_ sky130_fd_sc_hd__and2_1
X_2465_ _1053_ _0736_ _0743_ VGND VGND VPWR VPWR _0764_ sky130_fd_sc_hd__mux2_1
XFILLER_3_81 VGND VGND VPWR VPWR sky130_fd_sc_hd__fill_1
XFILLER_51_231 VGND VGND VPWR VPWR sky130_fd_sc_hd__decap_3
XFILLER_36_250 VGND VGND VPWR VPWR sky130_fd_sc_hd__fill_2
X_3017_ clknet_4_8_0_clk _0276_ _0113_ VGND VGND VPWR VPWR my_sum_sub.result\[0\]
+ sky130_fd_sc_hd__dfrtp_1
XFILLER_0_6 VGND VGND VPWR VPWR sky130_fd_sc_hd__decap_3
XFILLER_59_364 VGND VGND VPWR VPWR sky130_fd_sc_hd__decap_3
XFILLER_59_320 VGND VGND VPWR VPWR sky130_fd_sc_hd__decap_3
XFILLER_47_87 VGND VGND VPWR VPWR sky130_fd_sc_hd__fill_1
XFILLER_47_76 VGND VGND VPWR VPWR sky130_fd_sc_hd__decap_3
XTAP_TAPCELL_ROW_6_176 VGND VPWR sky130_fd_sc_hd__tapvpwrvgnd_1
X_2250_ my_sum_sub.al_b_larger _0528_ VGND VGND VPWR VPWR _0581_ sky130_fd_sc_hd__nand2_1
XFILLER_33_6 VGND VGND VPWR VPWR sky130_fd_sc_hd__decap_3
X_2181_ my_sum_sub.al_mb\[4\] net209 VGND VGND VPWR VPWR _0516_ sky130_fd_sc_hd__and2b_1
X_1965_ _1431_ _1435_ _1437_ _0373_ _1430_ VGND VGND VPWR VPWR _0374_ sky130_fd_sc_hd__a41oi_1
XFILLER_33_231 VGND VGND VPWR VPWR sky130_fd_sc_hd__decap_3
X_1896_ _1135_ _1439_ VGND VGND VPWR VPWR _1440_ sky130_fd_sc_hd__or2_1
X_2517_ _0765_ _0788_ VGND VGND VPWR VPWR _0816_ sky130_fd_sc_hd__xnor2_1
XFILLER_56_356 VGND VGND VPWR VPWR sky130_fd_sc_hd__decap_3
XFILLER_56_312 VGND VGND VPWR VPWR sky130_fd_sc_hd__fill_1
X_2379_ _0606_ _0667_ VGND VGND VPWR VPWR _0688_ sky130_fd_sc_hd__and2_1
X_2448_ _0736_ _0739_ _0744_ VGND VGND VPWR VPWR _0747_ sky130_fd_sc_hd__or3_1
XTAP_TAPCELL_ROW_3_157 VGND VPWR sky130_fd_sc_hd__tapvpwrvgnd_1
XFILLER_24_231 VGND VGND VPWR VPWR sky130_fd_sc_hd__decap_3
XFILLER_17_24 VGND VGND VPWR VPWR sky130_fd_sc_hd__decap_3
XFILLER_62_337 VGND VGND VPWR VPWR sky130_fd_sc_hd__decap_3
XFILLER_62_315 VGND VGND VPWR VPWR sky130_fd_sc_hd__decap_3
XFILLER_59_172 VGND VGND VPWR VPWR sky130_fd_sc_hd__decap_3
XFILLER_58_97 VGND VGND VPWR VPWR sky130_fd_sc_hd__decap_3
X_1750_ _1292_ _1293_ VGND VGND VPWR VPWR _1294_ sky130_fd_sc_hd__xnor2_1
XTAP_TAPCELL_ROW_60_527 VGND VPWR sky130_fd_sc_hd__tapvpwrvgnd_1
XFILLER_15_297 VGND VGND VPWR VPWR sky130_fd_sc_hd__decap_3
XTAP_TAPCELL_ROW_17_248 VGND VPWR sky130_fd_sc_hd__tapvpwrvgnd_1
X_1681_ _1223_ _1224_ VGND VGND VPWR VPWR _1225_ sky130_fd_sc_hd__nand2b_1
XFILLER_57_109 VGND VGND VPWR VPWR sky130_fd_sc_hd__decap_3
X_2233_ _0516_ _0540_ VGND VGND VPWR VPWR _0567_ sky130_fd_sc_hd__or2_1
X_2302_ _1153_ _0397_ _0624_ VGND VGND VPWR VPWR _0625_ sky130_fd_sc_hd__and3_1
XFILLER_31_3 VGND VGND VPWR VPWR sky130_fd_sc_hd__decap_3
X_2164_ net181 net176 net127 VGND VGND VPWR VPWR _0336_ sky130_fd_sc_hd__mux2_1
XFILLER_53_337 VGND VGND VPWR VPWR sky130_fd_sc_hd__decap_3
XFILLER_53_315 VGND VGND VPWR VPWR sky130_fd_sc_hd__decap_3
X_2095_ _0489_ _0490_ net280 VGND VGND VPWR VPWR _0491_ sky130_fd_sc_hd__o21a_1
XTAP_TAPCELL_ROW_0_138 VGND VPWR sky130_fd_sc_hd__tapvpwrvgnd_1
XTAP_TAPCELL_ROW_0_127 VGND VPWR sky130_fd_sc_hd__tapvpwrvgnd_1
XFILLER_0_60 VGND VGND VPWR VPWR sky130_fd_sc_hd__decap_3
X_1879_ _1183_ _1420_ VGND VGND VPWR VPWR _1423_ sky130_fd_sc_hd__nand2_2
X_1948_ net249 my_mul.x2\[11\] VGND VGND VPWR VPWR _1492_ sky130_fd_sc_hd__or2_1
X_2997_ clknet_4_0_0_clk net226 _0093_ VGND VGND VPWR VPWR my_divider.counter\[0\]
+ sky130_fd_sc_hd__dfrtp_1
XFILLER_0_116 VGND VGND VPWR VPWR sky130_fd_sc_hd__decap_3
XFILLER_56_197 VGND VGND VPWR VPWR sky130_fd_sc_hd__decap_3
XFILLER_56_120 VGND VGND VPWR VPWR sky130_fd_sc_hd__decap_3
XFILLER_44_315 VGND VGND VPWR VPWR sky130_fd_sc_hd__decap_3
XFILLER_29_367 VGND VGND VPWR VPWR sky130_fd_sc_hd__decap_3
XFILLER_29_345 VGND VGND VPWR VPWR sky130_fd_sc_hd__fill_2
XFILLER_60_21 VGND VGND VPWR VPWR sky130_fd_sc_hd__fill_2
XFILLER_12_278 VGND VGND VPWR VPWR sky130_fd_sc_hd__decap_3
XTAP_TAPCELL_ROW_14_229 VGND VPWR sky130_fd_sc_hd__tapvpwrvgnd_1
XFILLER_8_249 VGND VGND VPWR VPWR sky130_fd_sc_hd__decap_3
Xclkbuf_4_0_0_clk clknet_0_clk VGND VGND VPWR VPWR clknet_4_0_0_clk sky130_fd_sc_hd__clkbuf_8
XFILLER_39_109 VGND VGND VPWR VPWR sky130_fd_sc_hd__decap_3
XFILLER_62_189 VGND VGND VPWR VPWR sky130_fd_sc_hd__decap_3
XFILLER_62_156 VGND VGND VPWR VPWR sky130_fd_sc_hd__decap_3
XFILLER_62_134 VGND VGND VPWR VPWR sky130_fd_sc_hd__decap_3
XFILLER_50_329 VGND VGND VPWR VPWR sky130_fd_sc_hd__decap_3
XFILLER_50_307 VGND VGND VPWR VPWR sky130_fd_sc_hd__fill_1
XFILLER_47_197 VGND VGND VPWR VPWR sky130_fd_sc_hd__decap_3
XFILLER_35_359 VGND VGND VPWR VPWR sky130_fd_sc_hd__decap_3
X_2920_ net5 VGND VGND VPWR VPWR _0016_ sky130_fd_sc_hd__inv_2
X_1802_ my_mul.x2\[2\] acc_reg\[2\] _1344_ _1342_ VGND VGND VPWR VPWR _1346_ sky130_fd_sc_hd__a31o_1
X_1733_ _1265_ _1269_ my_mul.x2\[1\] VGND VGND VPWR VPWR _1277_ sky130_fd_sc_hd__o21ai_1
X_2851_ net2 VGND VGND VPWR VPWR _0132_ sky130_fd_sc_hd__inv_2
X_2782_ net74 _0650_ _0973_ VGND VGND VPWR VPWR _0251_ sky130_fd_sc_hd__mux2_1
X_1664_ _1196_ _1197_ _1199_ VGND VGND VPWR VPWR _1208_ sky130_fd_sc_hd__o21ai_1
Xhold238 my_sum_sub.cm_mant\[6\] VGND VGND VPWR VPWR net243 sky130_fd_sc_hd__dlygate4sd3_1
Xhold205 _0304_ VGND VGND VPWR VPWR net210 sky130_fd_sc_hd__dlygate4sd3_1
Xhold216 shift_out\[0\] VGND VGND VPWR VPWR net221 sky130_fd_sc_hd__dlygate4sd3_1
X_1595_ my_mul.x2\[10\] acc_reg\[10\] _1137_ VGND VGND VPWR VPWR _1139_ sky130_fd_sc_hd__a21oi_1
Xhold249 state\[2\] VGND VGND VPWR VPWR net254 sky130_fd_sc_hd__dlygate4sd3_1
Xhold227 _1088_ VGND VGND VPWR VPWR net232 sky130_fd_sc_hd__dlygate4sd3_1
X_2216_ _0517_ _0518_ VGND VGND VPWR VPWR _0551_ sky130_fd_sc_hd__nand2_1
XFILLER_38_153 VGND VGND VPWR VPWR sky130_fd_sc_hd__decap_3
X_2147_ _0504_ _0505_ VGND VGND VPWR VPWR _0506_ sky130_fd_sc_hd__nand2_2
XFILLER_53_134 VGND VGND VPWR VPWR sky130_fd_sc_hd__decap_3
X_2078_ shift_out\[5\] _1064_ _1097_ acc_reg\[4\] _1100_ VGND VGND VPWR VPWR _0477_
+ sky130_fd_sc_hd__a221o_1
XFILLER_39_88 VGND VGND VPWR VPWR sky130_fd_sc_hd__decap_3
XFILLER_29_120 VGND VGND VPWR VPWR sky130_fd_sc_hd__fill_1
XFILLER_55_21 VGND VGND VPWR VPWR sky130_fd_sc_hd__decap_3
XFILLER_32_307 VGND VGND VPWR VPWR sky130_fd_sc_hd__fill_1
XFILLER_29_197 VGND VGND VPWR VPWR sky130_fd_sc_hd__decap_3
XFILLER_29_175 VGND VGND VPWR VPWR sky130_fd_sc_hd__fill_2
XTAP_TAPCELL_ROW_27_310 VGND VPWR sky130_fd_sc_hd__tapvpwrvgnd_1
XFILLER_40_362 VGND VGND VPWR VPWR sky130_fd_sc_hd__fill_2
XFILLER_40_351 VGND VGND VPWR VPWR sky130_fd_sc_hd__fill_2
XFILLER_4_274 VGND VGND VPWR VPWR sky130_fd_sc_hd__decap_3
X_3050_ clknet_4_12_0_clk net143 _0146_ VGND VGND VPWR VPWR my_sum_sub.al_mb\[1\]
+ sky130_fd_sc_hd__dfrtp_1
X_2001_ _0409_ VGND VGND VPWR VPWR _0410_ sky130_fd_sc_hd__inv_2
XFILLER_50_126 VGND VGND VPWR VPWR sky130_fd_sc_hd__decap_3
XFILLER_35_178 VGND VGND VPWR VPWR sky130_fd_sc_hd__decap_3
X_2903_ net5 VGND VGND VPWR VPWR _0184_ sky130_fd_sc_hd__inv_2
X_1716_ _1250_ _1252_ VGND VGND VPWR VPWR _1260_ sky130_fd_sc_hd__xnor2_1
X_2765_ net138 _1032_ my_divider.en_r VGND VGND VPWR VPWR _0261_ sky130_fd_sc_hd__mux2_1
X_2696_ net115 _0972_ _0974_ net89 VGND VGND VPWR VPWR _0272_ sky130_fd_sc_hd__a22o_1
X_2834_ net2 VGND VGND VPWR VPWR _0115_ sky130_fd_sc_hd__inv_2
X_1647_ my_mul.x2\[5\] acc_reg\[4\] VGND VGND VPWR VPWR _1191_ sky130_fd_sc_hd__nand2_1
X_1578_ my_mul.x2\[9\] acc_reg\[9\] _1119_ VGND VGND VPWR VPWR _1122_ sky130_fd_sc_hd__and3_1
XFILLER_58_259 VGND VGND VPWR VPWR sky130_fd_sc_hd__decap_3
Xrebuffer20 my_sum_sub.cm_exp\[0\] VGND VGND VPWR VPWR net25 sky130_fd_sc_hd__dlygate4sd1_1
XFILLER_25_13 VGND VGND VPWR VPWR sky130_fd_sc_hd__decap_3
XFILLER_41_23 VGND VGND VPWR VPWR sky130_fd_sc_hd__fill_2
XFILLER_41_12 VGND VGND VPWR VPWR sky130_fd_sc_hd__fill_2
XFILLER_25_57 VGND VGND VPWR VPWR sky130_fd_sc_hd__fill_1
XFILLER_57_281 VGND VGND VPWR VPWR sky130_fd_sc_hd__fill_1
XFILLER_57_270 VGND VGND VPWR VPWR sky130_fd_sc_hd__decap_3
XFILLER_49_259 VGND VGND VPWR VPWR sky130_fd_sc_hd__decap_3
XFILLER_49_215 VGND VGND VPWR VPWR sky130_fd_sc_hd__fill_1
XFILLER_1_299 VGND VGND VPWR VPWR sky130_fd_sc_hd__decap_3
XTAP_TAPCELL_ROW_55_493 VGND VPWR sky130_fd_sc_hd__tapvpwrvgnd_1
XTAP_TAPCELL_ROW_47_438 VGND VPWR sky130_fd_sc_hd__tapvpwrvgnd_1
XFILLER_40_170 VGND VGND VPWR VPWR sky130_fd_sc_hd__decap_3
XTAP_TAPCELL_ROW_30_327 VGND VPWR sky130_fd_sc_hd__tapvpwrvgnd_1
X_2550_ _0827_ _0831_ _0837_ VGND VGND VPWR VPWR _0849_ sky130_fd_sc_hd__a21bo_1
XFILLER_9_322 VGND VGND VPWR VPWR sky130_fd_sc_hd__decap_3
XFILLER_15_90 VGND VGND VPWR VPWR sky130_fd_sc_hd__fill_2
X_1501_ my_sum_sub.al_mb\[0\] VGND VGND VPWR VPWR _1056_ sky130_fd_sc_hd__inv_2
X_2481_ _0720_ net6 _0779_ VGND VGND VPWR VPWR _0780_ sky130_fd_sc_hd__and3_1
XFILLER_55_218 VGND VGND VPWR VPWR sky130_fd_sc_hd__decap_3
XFILLER_48_281 VGND VGND VPWR VPWR sky130_fd_sc_hd__decap_3
X_3033_ clknet_4_14_0_clk net111 _0129_ VGND VGND VPWR VPWR my_sum_sub.al_exp\[0\]
+ sky130_fd_sc_hd__dfrtp_1
X_3102_ clknet_4_7_0_clk _0198_ _0013_ VGND VGND VPWR VPWR my_mul.x2\[7\] sky130_fd_sc_hd__dfrtp_4
X_2748_ _0994_ _1018_ VGND VGND VPWR VPWR _1019_ sky130_fd_sc_hd__nor2_1
X_2817_ net5 VGND VGND VPWR VPWR _0098_ sky130_fd_sc_hd__inv_2
X_2679_ _0958_ _0961_ _0966_ net78 _1057_ VGND VGND VPWR VPWR _0280_ sky130_fd_sc_hd__a32o_1
XFILLER_36_12 VGND VGND VPWR VPWR sky130_fd_sc_hd__decap_3
XFILLER_54_273 VGND VGND VPWR VPWR sky130_fd_sc_hd__decap_3
XFILLER_54_262 VGND VGND VPWR VPWR sky130_fd_sc_hd__fill_2
XFILLER_52_11 VGND VGND VPWR VPWR sky130_fd_sc_hd__decap_3
XTAP_TAPCELL_ROW_44_419 VGND VPWR sky130_fd_sc_hd__tapvpwrvgnd_1
XTAP_TAPCELL_ROW_52_474 VGND VPWR sky130_fd_sc_hd__tapvpwrvgnd_1
XFILLER_52_99 VGND VGND VPWR VPWR sky130_fd_sc_hd__decap_3
XFILLER_10_332 VGND VGND VPWR VPWR sky130_fd_sc_hd__decap_3
XFILLER_10_365 VGND VGND VPWR VPWR sky130_fd_sc_hd__decap_3
XTAP_TAPCELL_ROW_9_196 VGND VPWR sky130_fd_sc_hd__tapvpwrvgnd_1
XFILLER_45_251 VGND VGND VPWR VPWR sky130_fd_sc_hd__decap_3
XFILLER_37_218 VGND VGND VPWR VPWR sky130_fd_sc_hd__decap_3
XFILLER_28_9 VGND VGND VPWR VPWR sky130_fd_sc_hd__decap_3
XFILLER_60_298 VGND VGND VPWR VPWR sky130_fd_sc_hd__decap_3
XFILLER_60_265 VGND VGND VPWR VPWR sky130_fd_sc_hd__decap_3
X_1981_ _0387_ _0388_ _0389_ VGND VGND VPWR VPWR _0390_ sky130_fd_sc_hd__o21ai_1
XFILLER_61_3 VGND VGND VPWR VPWR sky130_fd_sc_hd__decap_3
X_2533_ _0782_ _0803_ VGND VGND VPWR VPWR _0832_ sky130_fd_sc_hd__xnor2_1
X_2602_ _0853_ _0900_ _0800_ VGND VGND VPWR VPWR _0901_ sky130_fd_sc_hd__a21o_1
X_2395_ net262 _0607_ _0695_ VGND VGND VPWR VPWR _0293_ sky130_fd_sc_hd__a21o_1
XFILLER_3_60 VGND VGND VPWR VPWR sky130_fd_sc_hd__fill_1
X_2464_ _0762_ VGND VGND VPWR VPWR _0763_ sky130_fd_sc_hd__inv_2
X_3016_ clknet_4_2_0_clk net36 _0112_ VGND VGND VPWR VPWR div_quotient\[6\] sky130_fd_sc_hd__dfrtp_1
XFILLER_51_276 VGND VGND VPWR VPWR sky130_fd_sc_hd__decap_3
XFILLER_51_265 VGND VGND VPWR VPWR sky130_fd_sc_hd__decap_3
XFILLER_3_317 VGND VGND VPWR VPWR sky130_fd_sc_hd__decap_3
XFILLER_59_343 VGND VGND VPWR VPWR sky130_fd_sc_hd__decap_3
XFILLER_59_332 VGND VGND VPWR VPWR sky130_fd_sc_hd__decap_3
XFILLER_47_55 VGND VGND VPWR VPWR sky130_fd_sc_hd__fill_1
XTAP_TAPCELL_ROW_6_177 VGND VPWR sky130_fd_sc_hd__tapvpwrvgnd_1
XFILLER_42_221 VGND VGND VPWR VPWR sky130_fd_sc_hd__decap_3
XFILLER_27_284 VGND VGND VPWR VPWR sky130_fd_sc_hd__decap_3
XFILLER_27_273 VGND VGND VPWR VPWR sky130_fd_sc_hd__decap_3
XFILLER_8_49 VGND VGND VPWR VPWR sky130_fd_sc_hd__fill_2
XFILLER_10_184 VGND VGND VPWR VPWR sky130_fd_sc_hd__fill_1
X_2180_ my_sum_sub.al_ma\[4\] net129 VGND VGND VPWR VPWR _0515_ sky130_fd_sc_hd__and2b_1
XFILLER_26_6 VGND VGND VPWR VPWR sky130_fd_sc_hd__decap_3
XFILLER_33_243 VGND VGND VPWR VPWR sky130_fd_sc_hd__decap_3
XFILLER_33_221 VGND VGND VPWR VPWR sky130_fd_sc_hd__decap_3
XFILLER_18_273 VGND VGND VPWR VPWR sky130_fd_sc_hd__decap_3
X_1895_ _1127_ _1134_ VGND VGND VPWR VPWR _1439_ sky130_fd_sc_hd__nor2_1
X_1964_ _1425_ _1444_ _1446_ _0372_ VGND VGND VPWR VPWR _0373_ sky130_fd_sc_hd__nor4b_2
X_2447_ _0736_ _0744_ VGND VGND VPWR VPWR _0746_ sky130_fd_sc_hd__nor2_1
X_2516_ _0795_ _0799_ _0805_ VGND VGND VPWR VPWR _0815_ sky130_fd_sc_hd__o21ai_2
XFILLER_0_309 VGND VGND VPWR VPWR sky130_fd_sc_hd__decap_3
XFILLER_56_368 VGND VGND VPWR VPWR sky130_fd_sc_hd__fill_2
X_2378_ _1055_ net206 _0665_ _0681_ _0687_ VGND VGND VPWR VPWR _0302_ sky130_fd_sc_hd__a221o_1
XFILLER_17_47 VGND VGND VPWR VPWR sky130_fd_sc_hd__fill_1
XPHY_EDGE_ROW_49_Left_112 VGND VGND VPWR VPWR sky130_fd_sc_hd__decap_3
XFILLER_59_151 VGND VGND VPWR VPWR sky130_fd_sc_hd__decap_3
XFILLER_59_140 VGND VGND VPWR VPWR sky130_fd_sc_hd__decap_3
XFILLER_58_32 VGND VGND VPWR VPWR sky130_fd_sc_hd__decap_3
XPHY_EDGE_ROW_58_Left_121 VGND VGND VPWR VPWR sky130_fd_sc_hd__decap_3
XFILLER_62_349 VGND VGND VPWR VPWR sky130_fd_sc_hd__decap_3
XFILLER_62_327 VGND VGND VPWR VPWR sky130_fd_sc_hd__decap_3
XFILLER_62_305 VGND VGND VPWR VPWR sky130_fd_sc_hd__decap_3
XFILLER_59_184 VGND VGND VPWR VPWR sky130_fd_sc_hd__decap_3
XTAP_TAPCELL_ROW_60_528 VGND VPWR sky130_fd_sc_hd__tapvpwrvgnd_1
XFILLER_30_235 VGND VGND VPWR VPWR sky130_fd_sc_hd__fill_1
XFILLER_30_213 VGND VGND VPWR VPWR sky130_fd_sc_hd__decap_3
X_1680_ _1209_ _1221_ VGND VGND VPWR VPWR _1224_ sky130_fd_sc_hd__xor2_1
X_2301_ _0364_ _0622_ _0623_ VGND VGND VPWR VPWR _0624_ sky130_fd_sc_hd__and3_1
X_2232_ my_sum_sub.al_b_larger net237 my_sum_sub.al_ma\[6\] VGND VGND VPWR VPWR _0566_
+ sky130_fd_sc_hd__or3b_1
XFILLER_38_368 VGND VGND VPWR VPWR sky130_fd_sc_hd__fill_2
XFILLER_38_357 VGND VGND VPWR VPWR sky130_fd_sc_hd__decap_3
XFILLER_38_346 VGND VGND VPWR VPWR sky130_fd_sc_hd__decap_3
X_2163_ shift_out\[0\] _1064_ _1096_ _0507_ net204 VGND VGND VPWR VPWR _0337_ sky130_fd_sc_hd__a32o_1
XFILLER_21_213 VGND VGND VPWR VPWR sky130_fd_sc_hd__fill_1
XTAP_TAPCELL_ROW_0_128 VGND VPWR sky130_fd_sc_hd__tapvpwrvgnd_1
X_2094_ net163 _1088_ _1090_ net48 VGND VGND VPWR VPWR _0490_ sky130_fd_sc_hd__a22o_1
X_1878_ _1183_ _1420_ VGND VGND VPWR VPWR _1422_ sky130_fd_sc_hd__and2_1
X_1947_ my_mul.x2\[7\] my_mul.x2\[6\] my_mul.x2\[5\] my_mul.x2\[4\] VGND VGND VPWR
+ VPWR _1491_ sky130_fd_sc_hd__or4_1
X_2996_ clknet_4_2_0_clk net102 _0092_ VGND VGND VPWR VPWR my_divider.divisor_reg\[7\]
+ sky130_fd_sc_hd__dfrtp_1
XFILLER_0_128 VGND VGND VPWR VPWR sky130_fd_sc_hd__decap_3
XFILLER_56_176 VGND VGND VPWR VPWR sky130_fd_sc_hd__decap_3
XFILLER_56_154 VGND VGND VPWR VPWR sky130_fd_sc_hd__decap_3
XFILLER_29_335 VGND VGND VPWR VPWR sky130_fd_sc_hd__fill_1
XFILLER_60_55 VGND VGND VPWR VPWR sky130_fd_sc_hd__decap_3
XFILLER_20_290 VGND VGND VPWR VPWR sky130_fd_sc_hd__fill_1
XFILLER_10_9 VGND VGND VPWR VPWR sky130_fd_sc_hd__decap_3
XFILLER_62_113 VGND VGND VPWR VPWR sky130_fd_sc_hd__decap_3
XFILLER_35_327 VGND VGND VPWR VPWR sky130_fd_sc_hd__decap_3
X_2850_ net2 VGND VGND VPWR VPWR _0131_ sky130_fd_sc_hd__inv_2
X_1801_ _1342_ _1344_ VGND VGND VPWR VPWR _1345_ sky130_fd_sc_hd__and2b_1
X_1732_ _1261_ _1274_ VGND VGND VPWR VPWR _1276_ sky130_fd_sc_hd__xor2_1
Xhold206 my_sum_sub.al_ma\[5\] VGND VGND VPWR VPWR net211 sky130_fd_sc_hd__dlygate4sd3_1
X_1663_ _1196_ _1203_ VGND VGND VPWR VPWR _1207_ sky130_fd_sc_hd__xor2_1
Xhold217 _0223_ VGND VGND VPWR VPWR net222 sky130_fd_sc_hd__dlygate4sd3_1
XFILLER_7_272 VGND VGND VPWR VPWR sky130_fd_sc_hd__decap_3
X_2781_ net93 _0643_ _0973_ VGND VGND VPWR VPWR _0252_ sky130_fd_sc_hd__mux2_1
Xhold239 _0325_ VGND VGND VPWR VPWR net244 sky130_fd_sc_hd__dlygate4sd3_1
X_1594_ my_mul.x2\[10\] acc_reg\[10\] _1137_ VGND VGND VPWR VPWR _1138_ sky130_fd_sc_hd__and3_1
Xhold228 bit_count\[2\] VGND VGND VPWR VPWR net233 sky130_fd_sc_hd__dlygate4sd3_1
XPHY_EDGE_ROW_7_Right_7 VGND VGND VPWR VPWR sky130_fd_sc_hd__decap_3
XFILLER_53_157 VGND VGND VPWR VPWR sky130_fd_sc_hd__decap_3
XFILLER_53_113 VGND VGND VPWR VPWR sky130_fd_sc_hd__decap_3
X_2215_ net129 my_sum_sub.al_ma\[4\] VGND VGND VPWR VPWR _0550_ sky130_fd_sc_hd__nand2_1
X_2077_ _0474_ _0475_ net280 VGND VGND VPWR VPWR _0476_ sky130_fd_sc_hd__o21a_1
XFILLER_38_165 VGND VGND VPWR VPWR sky130_fd_sc_hd__decap_3
X_2146_ state\[4\] _0501_ net121 VGND VGND VPWR VPWR _0505_ sky130_fd_sc_hd__or3b_1
XFILLER_53_179 VGND VGND VPWR VPWR sky130_fd_sc_hd__decap_3
XTAP_TAPCELL_ROW_36_366 VGND VPWR sky130_fd_sc_hd__tapvpwrvgnd_1
X_2979_ net2 VGND VGND VPWR VPWR _0075_ sky130_fd_sc_hd__inv_2
XFILLER_14_26 VGND VGND VPWR VPWR sky130_fd_sc_hd__fill_2
XFILLER_29_110 VGND VGND VPWR VPWR sky130_fd_sc_hd__fill_2
XFILLER_55_88 VGND VGND VPWR VPWR sky130_fd_sc_hd__decap_3
XFILLER_55_44 VGND VGND VPWR VPWR sky130_fd_sc_hd__decap_3
XFILLER_44_146 VGND VGND VPWR VPWR sky130_fd_sc_hd__fill_1
XTAP_TAPCELL_ROW_27_311 VGND VPWR sky130_fd_sc_hd__tapvpwrvgnd_1
XTAP_TAPCELL_ROW_10_200 VGND VPWR sky130_fd_sc_hd__tapvpwrvgnd_1
XFILLER_58_9 VGND VGND VPWR VPWR sky130_fd_sc_hd__decap_3
XFILLER_4_220 VGND VGND VPWR VPWR sky130_fd_sc_hd__decap_3
XFILLER_4_231 VGND VGND VPWR VPWR sky130_fd_sc_hd__decap_3
XFILLER_4_286 VGND VGND VPWR VPWR sky130_fd_sc_hd__decap_3
XFILLER_35_124 VGND VGND VPWR VPWR sky130_fd_sc_hd__fill_1
X_2000_ _1147_ _0404_ VGND VGND VPWR VPWR _0409_ sky130_fd_sc_hd__xor2_1
XFILLER_50_138 VGND VGND VPWR VPWR sky130_fd_sc_hd__fill_2
X_2902_ net5 VGND VGND VPWR VPWR _0183_ sky130_fd_sc_hd__inv_2
XTAP_TAPCELL_ROW_33_347 VGND VPWR sky130_fd_sc_hd__tapvpwrvgnd_1
XFILLER_31_363 VGND VGND VPWR VPWR sky130_fd_sc_hd__decap_3
XFILLER_23_319 VGND VGND VPWR VPWR sky130_fd_sc_hd__fill_2
X_2833_ net2 VGND VGND VPWR VPWR _0114_ sky130_fd_sc_hd__inv_2
XFILLER_16_360 VGND VGND VPWR VPWR sky130_fd_sc_hd__decap_3
X_1646_ my_mul.x2\[6\] acc_reg\[3\] acc_reg\[2\] VGND VGND VPWR VPWR _1190_ sky130_fd_sc_hd__and3_1
X_1715_ _1254_ _1258_ VGND VGND VPWR VPWR _1259_ sky130_fd_sc_hd__and2_1
X_2764_ _1030_ _1031_ _0667_ _0973_ VGND VGND VPWR VPWR _1032_ sky130_fd_sc_hd__a2bb2o_1
X_2695_ net89 _0972_ _0974_ div_quotient\[4\] VGND VGND VPWR VPWR _0273_ sky130_fd_sc_hd__a22o_1
XFILLER_58_238 VGND VGND VPWR VPWR sky130_fd_sc_hd__decap_3
X_1577_ _1120_ VGND VGND VPWR VPWR _1121_ sky130_fd_sc_hd__inv_2
X_2129_ net83 net97 _0500_ VGND VGND VPWR VPWR _0201_ sky130_fd_sc_hd__mux2_1
Xrebuffer21 net25 VGND VGND VPWR VPWR net26 sky130_fd_sc_hd__dlygate4sd1_1
Xrebuffer10 net14 VGND VGND VPWR VPWR net15 sky130_fd_sc_hd__dlygate4sd1_1
XFILLER_22_330 VGND VGND VPWR VPWR sky130_fd_sc_hd__decap_3
XFILLER_1_234 VGND VGND VPWR VPWR sky130_fd_sc_hd__decap_3
XFILLER_1_223 VGND VGND VPWR VPWR sky130_fd_sc_hd__fill_1
XTAP_TAPCELL_ROW_47_439 VGND VPWR sky130_fd_sc_hd__tapvpwrvgnd_1
XFILLER_17_113 VGND VGND VPWR VPWR sky130_fd_sc_hd__decap_3
XTAP_TAPCELL_ROW_55_494 VGND VPWR sky130_fd_sc_hd__tapvpwrvgnd_1
XFILLER_32_138 VGND VGND VPWR VPWR sky130_fd_sc_hd__fill_2
XTAP_TAPCELL_ROW_30_328 VGND VPWR sky130_fd_sc_hd__tapvpwrvgnd_1
XFILLER_56_6 VGND VGND VPWR VPWR sky130_fd_sc_hd__decap_3
X_1500_ net282 VGND VGND VPWR VPWR _1055_ sky130_fd_sc_hd__inv_6
X_2480_ _0772_ _0777_ _0778_ VGND VGND VPWR VPWR _0779_ sky130_fd_sc_hd__o21a_1
X_3101_ clknet_4_0_0_clk net240 _0012_ VGND VGND VPWR VPWR my_mul.x2\[6\] sky130_fd_sc_hd__dfrtp_4
X_3032_ clknet_4_11_0_clk net149 _0128_ VGND VGND VPWR VPWR my_sum_sub.result\[15\]
+ sky130_fd_sc_hd__dfrtp_1
X_2816_ net2 VGND VGND VPWR VPWR _0097_ sky130_fd_sc_hd__inv_2
XFILLER_16_190 VGND VGND VPWR VPWR sky130_fd_sc_hd__decap_3
X_1629_ my_mul.x2\[6\] acc_reg\[4\] acc_reg\[3\] VGND VGND VPWR VPWR _1173_ sky130_fd_sc_hd__and3_1
X_2747_ _0985_ _0986_ _0993_ VGND VGND VPWR VPWR _1018_ sky130_fd_sc_hd__nor3_1
X_2678_ _0800_ _0894_ _0965_ VGND VGND VPWR VPWR _0966_ sky130_fd_sc_hd__a21o_1
XFILLER_36_24 VGND VGND VPWR VPWR sky130_fd_sc_hd__decap_3
XFILLER_54_285 VGND VGND VPWR VPWR sky130_fd_sc_hd__fill_2
XFILLER_54_241 VGND VGND VPWR VPWR sky130_fd_sc_hd__decap_3
XTAP_TAPCELL_ROW_52_475 VGND VPWR sky130_fd_sc_hd__tapvpwrvgnd_1
XFILLER_52_23 VGND VGND VPWR VPWR sky130_fd_sc_hd__decap_3
XFILLER_14_138 VGND VGND VPWR VPWR sky130_fd_sc_hd__fill_2
XFILLER_6_315 VGND VGND VPWR VPWR sky130_fd_sc_hd__decap_3
XFILLER_6_337 VGND VGND VPWR VPWR sky130_fd_sc_hd__decap_3
XFILLER_45_263 VGND VGND VPWR VPWR sky130_fd_sc_hd__decap_3
XFILLER_60_277 VGND VGND VPWR VPWR sky130_fd_sc_hd__decap_3
X_1980_ _1107_ _1110_ VGND VGND VPWR VPWR _0389_ sky130_fd_sc_hd__xnor2_1
XFILLER_54_3 VGND VGND VPWR VPWR sky130_fd_sc_hd__decap_3
X_2601_ my_sum_sub.cm_mant\[3\] _0742_ _0898_ my_sum_sub.cm_mant\[6\] _0899_ VGND
+ VGND VPWR VPWR _0900_ sky130_fd_sc_hd__a221o_1
X_2532_ _0821_ _0830_ VGND VGND VPWR VPWR _0831_ sky130_fd_sc_hd__and2_1
Xrebuffer1 _0748_ VGND VGND VPWR VPWR net6 sky130_fd_sc_hd__buf_1
X_2463_ _0747_ _0754_ VGND VGND VPWR VPWR _0762_ sky130_fd_sc_hd__xnor2_2
X_2394_ net113 _1055_ _0606_ acc_reg\[8\] VGND VGND VPWR VPWR _0695_ sky130_fd_sc_hd__a22o_1
X_3015_ clknet_4_2_0_clk net166 _0111_ VGND VGND VPWR VPWR div_quotient\[5\] sky130_fd_sc_hd__dfrtp_1
XFILLER_36_285 VGND VGND VPWR VPWR sky130_fd_sc_hd__fill_2
XFILLER_59_355 VGND VGND VPWR VPWR sky130_fd_sc_hd__decap_3
XFILLER_59_311 VGND VGND VPWR VPWR sky130_fd_sc_hd__decap_3
XFILLER_3_329 VGND VGND VPWR VPWR sky130_fd_sc_hd__decap_3
XFILLER_47_67 VGND VGND VPWR VPWR sky130_fd_sc_hd__decap_3
XFILLER_47_34 VGND VGND VPWR VPWR sky130_fd_sc_hd__decap_3
XFILLER_27_263 VGND VGND VPWR VPWR sky130_fd_sc_hd__fill_1
XFILLER_27_241 VGND VGND VPWR VPWR sky130_fd_sc_hd__fill_2
XFILLER_42_244 VGND VGND VPWR VPWR sky130_fd_sc_hd__decap_3
XFILLER_8_17 VGND VGND VPWR VPWR sky130_fd_sc_hd__decap_3
XFILLER_19_6 VGND VGND VPWR VPWR sky130_fd_sc_hd__decap_3
X_1963_ _1447_ _1463_ _0370_ _0371_ VGND VGND VPWR VPWR _0372_ sky130_fd_sc_hd__nor4_1
X_1894_ _1437_ VGND VGND VPWR VPWR _1438_ sky130_fd_sc_hd__inv_2
X_2446_ _0744_ VGND VGND VPWR VPWR _0745_ sky130_fd_sc_hd__inv_2
X_2515_ _0759_ _0813_ VGND VGND VPWR VPWR _0814_ sky130_fd_sc_hd__xor2_1
XFILLER_56_347 VGND VGND VPWR VPWR sky130_fd_sc_hd__decap_3
X_2377_ _0606_ _0658_ VGND VGND VPWR VPWR _0687_ sky130_fd_sc_hd__and2_1
XFILLER_24_299 VGND VGND VPWR VPWR sky130_fd_sc_hd__fill_1
XFILLER_24_244 VGND VGND VPWR VPWR sky130_fd_sc_hd__decap_3
XFILLER_24_222 VGND VGND VPWR VPWR sky130_fd_sc_hd__decap_3
XFILLER_3_159 VGND VGND VPWR VPWR sky130_fd_sc_hd__fill_2
XFILLER_59_196 VGND VGND VPWR VPWR sky130_fd_sc_hd__decap_3
XFILLER_59_163 VGND VGND VPWR VPWR sky130_fd_sc_hd__decap_3
XFILLER_58_88 VGND VGND VPWR VPWR sky130_fd_sc_hd__decap_3
XFILLER_58_66 VGND VGND VPWR VPWR sky130_fd_sc_hd__fill_2
XFILLER_47_325 VGND VGND VPWR VPWR sky130_fd_sc_hd__decap_3
XFILLER_30_203 VGND VGND VPWR VPWR sky130_fd_sc_hd__decap_3
XFILLER_15_277 VGND VGND VPWR VPWR sky130_fd_sc_hd__decap_3
XFILLER_30_225 VGND VGND VPWR VPWR sky130_fd_sc_hd__decap_3
XFILLER_23_80 VGND VGND VPWR VPWR sky130_fd_sc_hd__fill_2
X_2231_ _0546_ _0561_ VGND VGND VPWR VPWR _0565_ sky130_fd_sc_hd__and2b_1
X_2300_ net262 net110 _1492_ _0360_ VGND VGND VPWR VPWR _0623_ sky130_fd_sc_hd__or4_4
X_2093_ _0368_ _0379_ _0459_ _0488_ VGND VGND VPWR VPWR _0489_ sky130_fd_sc_hd__and4_1
XTAP_TAPCELL_ROW_0_129 VGND VPWR sky130_fd_sc_hd__tapvpwrvgnd_1
X_2162_ _1064_ _1065_ net202 VGND VGND VPWR VPWR _0507_ sky130_fd_sc_hd__a21oi_1
XFILLER_17_3 VGND VGND VPWR VPWR sky130_fd_sc_hd__decap_3
XFILLER_61_361 VGND VGND VPWR VPWR sky130_fd_sc_hd__decap_3
XFILLER_21_225 VGND VGND VPWR VPWR sky130_fd_sc_hd__fill_1
XFILLER_0_73 VGND VGND VPWR VPWR sky130_fd_sc_hd__decap_3
X_2995_ clknet_4_2_0_clk net299 _0091_ VGND VGND VPWR VPWR my_divider.divisor_reg\[6\]
+ sky130_fd_sc_hd__dfrtp_1
XFILLER_9_60 VGND VGND VPWR VPWR sky130_fd_sc_hd__fill_2
X_1877_ _1156_ _1182_ VGND VGND VPWR VPWR _1421_ sky130_fd_sc_hd__nand2_1
X_1946_ _1434_ _1489_ VGND VGND VPWR VPWR _1490_ sky130_fd_sc_hd__nor2_1
XFILLER_56_111 VGND VGND VPWR VPWR sky130_fd_sc_hd__decap_3
X_2429_ _0721_ _0724_ _0727_ _0720_ VGND VGND VPWR VPWR _0728_ sky130_fd_sc_hd__or4b_4
XTAP_TAPCELL_ROW_39_386 VGND VPWR sky130_fd_sc_hd__tapvpwrvgnd_1
Xsplit15 my_sum_sub.cm_mant\[8\] VGND VGND VPWR VPWR net20 sky130_fd_sc_hd__buf_1
XFILLER_60_45 VGND VGND VPWR VPWR sky130_fd_sc_hd__decap_3
XFILLER_60_12 VGND VGND VPWR VPWR sky130_fd_sc_hd__decap_3
XTAP_TAPCELL_ROW_22_275 VGND VPWR sky130_fd_sc_hd__tapvpwrvgnd_1
XFILLER_62_103 VGND VGND VPWR VPWR sky130_fd_sc_hd__decap_3
XFILLER_47_188 VGND VGND VPWR VPWR sky130_fd_sc_hd__decap_3
XFILLER_47_166 VGND VGND VPWR VPWR sky130_fd_sc_hd__fill_2
XFILLER_47_100 VGND VGND VPWR VPWR sky130_fd_sc_hd__decap_3
XFILLER_62_169 VGND VGND VPWR VPWR sky130_fd_sc_hd__fill_2
XFILLER_62_147 VGND VGND VPWR VPWR sky130_fd_sc_hd__decap_3
X_1800_ my_mul.x2\[3\] acc_reg\[1\] acc_reg\[0\] my_mul.x2\[4\] VGND VGND VPWR VPWR
+ _1344_ sky130_fd_sc_hd__a22o_1
XFILLER_50_309 VGND VGND VPWR VPWR sky130_fd_sc_hd__fill_2
XTAP_TAPCELL_ROW_13_220 VGND VPWR sky130_fd_sc_hd__tapvpwrvgnd_1
X_1731_ _1261_ _1274_ VGND VGND VPWR VPWR _1275_ sky130_fd_sc_hd__nand2_1
Xhold207 _0305_ VGND VGND VPWR VPWR net212 sky130_fd_sc_hd__dlygate4sd3_1
X_1662_ _1205_ _1185_ VGND VGND VPWR VPWR _1206_ sky130_fd_sc_hd__nand2b_1
Xhold229 _1081_ VGND VGND VPWR VPWR net234 sky130_fd_sc_hd__dlygate4sd3_1
X_2780_ net136 _0637_ _0973_ VGND VGND VPWR VPWR _0253_ sky130_fd_sc_hd__mux2_1
Xhold218 op_reg\[1\] VGND VGND VPWR VPWR net223 sky130_fd_sc_hd__dlygate4sd3_1
X_2214_ my_sum_sub.al_mb\[5\] my_sum_sub.al_ma\[5\] VGND VGND VPWR VPWR _0549_ sky130_fd_sc_hd__nand2_1
X_1593_ my_mul.x2\[11\] acc_reg\[11\] VGND VGND VPWR VPWR _1137_ sky130_fd_sc_hd__xor2_2
XFILLER_53_169 VGND VGND VPWR VPWR sky130_fd_sc_hd__decap_3
XFILLER_53_125 VGND VGND VPWR VPWR sky130_fd_sc_hd__decap_3
XFILLER_38_188 VGND VGND VPWR VPWR sky130_fd_sc_hd__decap_3
XFILLER_38_144 VGND VGND VPWR VPWR sky130_fd_sc_hd__decap_3
XTAP_TAPCELL_ROW_36_367 VGND VPWR sky130_fd_sc_hd__tapvpwrvgnd_1
XFILLER_26_339 VGND VGND VPWR VPWR sky130_fd_sc_hd__fill_2
X_2145_ net295 _0412_ _0504_ VGND VGND VPWR VPWR _0352_ sky130_fd_sc_hd__mux2_1
X_2076_ div_quotient\[4\] _1088_ _1090_ net78 VGND VGND VPWR VPWR _0475_ sky130_fd_sc_hd__a22o_1
X_1929_ _1413_ _1415_ VGND VGND VPWR VPWR _1473_ sky130_fd_sc_hd__xnor2_1
X_2978_ net5 VGND VGND VPWR VPWR _0074_ sky130_fd_sc_hd__inv_2
XFILLER_14_38 VGND VGND VPWR VPWR sky130_fd_sc_hd__fill_1
XFILLER_30_26 VGND VGND VPWR VPWR sky130_fd_sc_hd__fill_2
XFILLER_55_12 VGND VGND VPWR VPWR sky130_fd_sc_hd__decap_3
XFILLER_17_317 VGND VGND VPWR VPWR sky130_fd_sc_hd__fill_1
XFILLER_44_158 VGND VGND VPWR VPWR sky130_fd_sc_hd__fill_2
XFILLER_32_309 VGND VGND VPWR VPWR sky130_fd_sc_hd__fill_1
XTAP_TAPCELL_ROW_27_312 VGND VPWR sky130_fd_sc_hd__tapvpwrvgnd_1
XFILLER_25_350 VGND VGND VPWR VPWR sky130_fd_sc_hd__decap_3
XTAP_TAPCELL_ROW_10_201 VGND VPWR sky130_fd_sc_hd__tapvpwrvgnd_1
XFILLER_4_243 VGND VGND VPWR VPWR sky130_fd_sc_hd__decap_3
XFILLER_4_298 VGND VGND VPWR VPWR sky130_fd_sc_hd__decap_3
XFILLER_35_169 VGND VGND VPWR VPWR sky130_fd_sc_hd__decap_3
Xhold90 shift_in\[13\] VGND VGND VPWR VPWR net95 sky130_fd_sc_hd__dlygate4sd3_1
XFILLER_50_117 VGND VGND VPWR VPWR sky130_fd_sc_hd__decap_3
X_2901_ net5 VGND VGND VPWR VPWR _0182_ sky130_fd_sc_hd__inv_2
XTAP_TAPCELL_ROW_33_348 VGND VPWR sky130_fd_sc_hd__tapvpwrvgnd_1
X_2832_ net2 VGND VGND VPWR VPWR _0113_ sky130_fd_sc_hd__inv_2
X_2763_ my_divider.remainder_reg\[0\] my_divider.divisor_reg\[0\] _1002_ _0973_ VGND
+ VGND VPWR VPWR _1031_ sky130_fd_sc_hd__a31o_1
X_1645_ _1175_ _1188_ VGND VGND VPWR VPWR _1189_ sky130_fd_sc_hd__nor2_1
X_1714_ _1232_ _1249_ _1253_ VGND VGND VPWR VPWR _1258_ sky130_fd_sc_hd__or3_1
X_1576_ my_mul.x2\[9\] acc_reg\[9\] _1119_ VGND VGND VPWR VPWR _1120_ sky130_fd_sc_hd__a21oi_1
X_2694_ div_quotient\[4\] _0972_ _0974_ net165 VGND VGND VPWR VPWR _0274_ sky130_fd_sc_hd__a22o_1
XFILLER_58_217 VGND VGND VPWR VPWR sky130_fd_sc_hd__decap_3
Xrebuffer11 my_sum_sub.cm_exp\[2\] VGND VGND VPWR VPWR net16 sky130_fd_sc_hd__dlygate4sd1_1
X_2059_ _1471_ _1485_ _1462_ VGND VGND VPWR VPWR _0460_ sky130_fd_sc_hd__or3b_1
XFILLER_41_139 VGND VGND VPWR VPWR sky130_fd_sc_hd__decap_3
X_2128_ net91 net105 _0500_ VGND VGND VPWR VPWR _0202_ sky130_fd_sc_hd__mux2_1
XFILLER_22_342 VGND VGND VPWR VPWR sky130_fd_sc_hd__fill_1
XFILLER_14_309 VGND VGND VPWR VPWR sky130_fd_sc_hd__decap_3
XFILLER_49_228 VGND VGND VPWR VPWR sky130_fd_sc_hd__decap_3
XFILLER_49_206 VGND VGND VPWR VPWR sky130_fd_sc_hd__fill_2
XFILLER_1_213 VGND VGND VPWR VPWR sky130_fd_sc_hd__fill_2
XTAP_TAPCELL_ROW_55_495 VGND VPWR sky130_fd_sc_hd__tapvpwrvgnd_1
XTAP_TAPCELL_ROW_30_329 VGND VPWR sky130_fd_sc_hd__tapvpwrvgnd_1
XFILLER_9_313 VGND VGND VPWR VPWR sky130_fd_sc_hd__fill_1
XFILLER_9_335 VGND VGND VPWR VPWR sky130_fd_sc_hd__fill_1
XFILLER_49_6 VGND VGND VPWR VPWR sky130_fd_sc_hd__decap_3
XFILLER_55_209 VGND VGND VPWR VPWR sky130_fd_sc_hd__decap_3
XFILLER_48_261 VGND VGND VPWR VPWR sky130_fd_sc_hd__fill_2
X_3100_ clknet_4_7_0_clk _0196_ _0011_ VGND VGND VPWR VPWR my_mul.x2\[5\] sky130_fd_sc_hd__dfrtp_4
XFILLER_0_290 VGND VGND VPWR VPWR sky130_fd_sc_hd__decap_3
X_3031_ clknet_4_3_0_clk net126 _0127_ VGND VGND VPWR VPWR my_sum_sub.result\[14\]
+ sky130_fd_sc_hd__dfrtp_1
XFILLER_31_150 VGND VGND VPWR VPWR sky130_fd_sc_hd__decap_3
X_2815_ net2 VGND VGND VPWR VPWR _0096_ sky130_fd_sc_hd__inv_2
X_2746_ net200 _0974_ _1016_ _0972_ _1017_ VGND VGND VPWR VPWR _0265_ sky130_fd_sc_hd__a221o_1
X_1628_ _1159_ _1171_ VGND VGND VPWR VPWR _1172_ sky130_fd_sc_hd__nor2_1
X_1559_ acc_reg\[15\] _1097_ _1100_ _1103_ VGND VGND VPWR VPWR _1104_ sky130_fd_sc_hd__a211o_1
X_2677_ _0799_ _0900_ _0948_ VGND VGND VPWR VPWR _0965_ sky130_fd_sc_hd__and3_1
XFILLER_54_253 VGND VGND VPWR VPWR sky130_fd_sc_hd__decap_3
XFILLER_54_220 VGND VGND VPWR VPWR sky130_fd_sc_hd__decap_3
XTAP_TAPCELL_ROW_52_476 VGND VPWR sky130_fd_sc_hd__tapvpwrvgnd_1
XFILLER_52_68 VGND VGND VPWR VPWR sky130_fd_sc_hd__decap_3
XFILLER_22_161 VGND VGND VPWR VPWR sky130_fd_sc_hd__fill_2
XFILLER_10_301 VGND VGND VPWR VPWR sky130_fd_sc_hd__decap_3
XFILLER_10_323 VGND VGND VPWR VPWR sky130_fd_sc_hd__decap_3
XFILLER_6_349 VGND VGND VPWR VPWR sky130_fd_sc_hd__fill_1
XFILLER_60_256 VGND VGND VPWR VPWR sky130_fd_sc_hd__decap_3
XFILLER_60_223 VGND VGND VPWR VPWR sky130_fd_sc_hd__fill_1
XFILLER_60_212 VGND VGND VPWR VPWR sky130_fd_sc_hd__fill_2
XFILLER_45_242 VGND VGND VPWR VPWR sky130_fd_sc_hd__decap_3
XFILLER_60_289 VGND VGND VPWR VPWR sky130_fd_sc_hd__decap_3
X_2600_ my_sum_sub.cm_mant\[7\] _0796_ VGND VGND VPWR VPWR _0899_ sky130_fd_sc_hd__and2_1
Xrebuffer2 _0752_ VGND VGND VPWR VPWR net7 sky130_fd_sc_hd__buf_2
XFILLER_47_3 VGND VGND VPWR VPWR sky130_fd_sc_hd__decap_3
X_2393_ net252 _0607_ _0694_ VGND VGND VPWR VPWR _0294_ sky130_fd_sc_hd__a21o_1
X_2531_ _0810_ _0829_ VGND VGND VPWR VPWR _0830_ sky130_fd_sc_hd__nor2_1
X_2462_ _0740_ _0745_ _0760_ VGND VGND VPWR VPWR _0761_ sky130_fd_sc_hd__a21o_1
XFILLER_36_242 VGND VGND VPWR VPWR sky130_fd_sc_hd__fill_1
XFILLER_36_231 VGND VGND VPWR VPWR sky130_fd_sc_hd__decap_3
XFILLER_3_51 VGND VGND VPWR VPWR sky130_fd_sc_hd__decap_3
X_3014_ clknet_4_2_0_clk net90 _0110_ VGND VGND VPWR VPWR div_quotient\[4\] sky130_fd_sc_hd__dfrtp_1
XFILLER_51_234 VGND VGND VPWR VPWR sky130_fd_sc_hd__decap_3
XFILLER_51_223 VGND VGND VPWR VPWR sky130_fd_sc_hd__fill_1
X_2729_ _1002_ _1003_ VGND VGND VPWR VPWR _1004_ sky130_fd_sc_hd__nand2_1
XFILLER_59_367 VGND VGND VPWR VPWR sky130_fd_sc_hd__decap_3
XFILLER_59_323 VGND VGND VPWR VPWR sky130_fd_sc_hd__decap_3
XFILLER_0_9 VGND VGND VPWR VPWR sky130_fd_sc_hd__decap_3
XFILLER_47_79 VGND VGND VPWR VPWR sky130_fd_sc_hd__fill_2
XPHY_EDGE_ROW_29_Right_29 VGND VGND VPWR VPWR sky130_fd_sc_hd__decap_3
XPHY_EDGE_ROW_38_Right_38 VGND VGND VPWR VPWR sky130_fd_sc_hd__decap_3
XFILLER_8_29 VGND VGND VPWR VPWR sky130_fd_sc_hd__decap_3
XFILLER_33_9 VGND VGND VPWR VPWR sky130_fd_sc_hd__fill_1
XFILLER_10_197 VGND VGND VPWR VPWR sky130_fd_sc_hd__decap_3
XPHY_EDGE_ROW_47_Right_47 VGND VGND VPWR VPWR sky130_fd_sc_hd__decap_3
XPHY_EDGE_ROW_25_Left_88 VGND VGND VPWR VPWR sky130_fd_sc_hd__decap_3
XPHY_EDGE_ROW_56_Right_56 VGND VGND VPWR VPWR sky130_fd_sc_hd__decap_3
X_1962_ _1467_ _1471_ _1481_ VGND VGND VPWR VPWR _0371_ sky130_fd_sc_hd__or3_1
XFILLER_33_234 VGND VGND VPWR VPWR sky130_fd_sc_hd__decap_3
XFILLER_33_212 VGND VGND VPWR VPWR sky130_fd_sc_hd__decap_3
XFILLER_18_264 VGND VGND VPWR VPWR sky130_fd_sc_hd__fill_2
X_1893_ _1141_ _1436_ VGND VGND VPWR VPWR _1437_ sky130_fd_sc_hd__nor2_2
XFILLER_56_304 VGND VGND VPWR VPWR sky130_fd_sc_hd__decap_3
X_2376_ _1055_ net213 _0656_ _0681_ _0686_ VGND VGND VPWR VPWR _0303_ sky130_fd_sc_hd__a221o_1
X_2445_ _0728_ _0731_ _0743_ VGND VGND VPWR VPWR _0744_ sky130_fd_sc_hd__a21o_4
X_2514_ _0790_ _0807_ VGND VGND VPWR VPWR _0813_ sky130_fd_sc_hd__nor2_1
XFILLER_56_359 VGND VGND VPWR VPWR sky130_fd_sc_hd__decap_3
XFILLER_24_234 VGND VGND VPWR VPWR sky130_fd_sc_hd__decap_3
XFILLER_33_48 VGND VGND VPWR VPWR sky130_fd_sc_hd__fill_2
XFILLER_24_256 VGND VGND VPWR VPWR sky130_fd_sc_hd__decap_3
XFILLER_58_12 VGND VGND VPWR VPWR sky130_fd_sc_hd__decap_3
XFILLER_3_105 VGND VGND VPWR VPWR sky130_fd_sc_hd__decap_3
XFILLER_59_175 VGND VGND VPWR VPWR sky130_fd_sc_hd__decap_3
XFILLER_59_120 VGND VGND VPWR VPWR sky130_fd_sc_hd__decap_3
XFILLER_58_78 VGND VGND VPWR VPWR sky130_fd_sc_hd__decap_3
XFILLER_62_318 VGND VGND VPWR VPWR sky130_fd_sc_hd__decap_3
XFILLER_15_212 VGND VGND VPWR VPWR sky130_fd_sc_hd__decap_3
XTAP_TAPCELL_ROW_25_295 VGND VPWR sky130_fd_sc_hd__tapvpwrvgnd_1
X_2230_ net8 _0564_ net127 VGND VGND VPWR VPWR _0327_ sky130_fd_sc_hd__mux2_1
XFILLER_31_6 VGND VGND VPWR VPWR sky130_fd_sc_hd__fill_2
XFILLER_2_160 VGND VGND VPWR VPWR sky130_fd_sc_hd__decap_3
XFILLER_53_318 VGND VGND VPWR VPWR sky130_fd_sc_hd__decap_3
X_2092_ _1462_ _1485_ VGND VGND VPWR VPWR _0488_ sky130_fd_sc_hd__nand2b_1
X_2161_ net306 _0496_ _0504_ VGND VGND VPWR VPWR _0338_ sky130_fd_sc_hd__mux2_1
XFILLER_0_63 VGND VGND VPWR VPWR sky130_fd_sc_hd__decap_3
XFILLER_0_85 VGND VGND VPWR VPWR sky130_fd_sc_hd__fill_1
XFILLER_61_340 VGND VGND VPWR VPWR sky130_fd_sc_hd__decap_3
X_1945_ _1438_ _1444_ _1446_ _1488_ VGND VGND VPWR VPWR _1489_ sky130_fd_sc_hd__or4_2
XFILLER_21_204 VGND VGND VPWR VPWR sky130_fd_sc_hd__fill_1
X_2994_ clknet_4_2_0_clk net137 _0090_ VGND VGND VPWR VPWR my_divider.divisor_reg\[5\]
+ sky130_fd_sc_hd__dfrtp_1
XFILLER_9_94 VGND VGND VPWR VPWR sky130_fd_sc_hd__fill_2
XTAP_TAPCELL_ROW_16_240 VGND VPWR sky130_fd_sc_hd__tapvpwrvgnd_1
X_1876_ _1416_ _1419_ _1169_ _1206_ VGND VGND VPWR VPWR _1420_ sky130_fd_sc_hd__o2bb2a_2
XFILLER_56_123 VGND VGND VPWR VPWR sky130_fd_sc_hd__decap_3
X_2359_ net158 _0623_ VGND VGND VPWR VPWR _0675_ sky130_fd_sc_hd__and2_1
X_2428_ _0710_ _0711_ _0726_ _0709_ VGND VGND VPWR VPWR _0727_ sky130_fd_sc_hd__a22o_1
XFILLER_0_119 VGND VGND VPWR VPWR sky130_fd_sc_hd__decap_3
XFILLER_44_318 VGND VGND VPWR VPWR sky130_fd_sc_hd__decap_3
XFILLER_44_307 VGND VGND VPWR VPWR sky130_fd_sc_hd__fill_1
XTAP_TAPCELL_ROW_39_387 VGND VPWR sky130_fd_sc_hd__tapvpwrvgnd_1
XFILLER_60_79 VGND VGND VPWR VPWR sky130_fd_sc_hd__fill_1
XTAP_TAPCELL_ROW_22_276 VGND VPWR sky130_fd_sc_hd__tapvpwrvgnd_1
XFILLER_62_137 VGND VGND VPWR VPWR sky130_fd_sc_hd__decap_3
XFILLER_47_156 VGND VGND VPWR VPWR sky130_fd_sc_hd__fill_1
XFILLER_35_318 VGND VGND VPWR VPWR sky130_fd_sc_hd__decap_3
XFILLER_62_159 VGND VGND VPWR VPWR sky130_fd_sc_hd__decap_3
XTAP_TAPCELL_ROW_13_221 VGND VPWR sky130_fd_sc_hd__tapvpwrvgnd_1
X_1730_ _1237_ _1238_ _1273_ VGND VGND VPWR VPWR _1274_ sky130_fd_sc_hd__o21ai_1
X_1661_ _1196_ _1204_ _1201_ VGND VGND VPWR VPWR _1205_ sky130_fd_sc_hd__a21oi_1
Xhold208 my_sum_sub.al_ma\[3\] VGND VGND VPWR VPWR net213 sky130_fd_sc_hd__dlygate4sd3_1
X_1592_ _1122_ _1132_ _1135_ _1121_ VGND VGND VPWR VPWR _1136_ sky130_fd_sc_hd__o31ai_1
XFILLER_11_270 VGND VGND VPWR VPWR sky130_fd_sc_hd__decap_3
XFILLER_11_281 VGND VGND VPWR VPWR sky130_fd_sc_hd__decap_3
Xhold219 _1085_ VGND VGND VPWR VPWR net224 sky130_fd_sc_hd__dlygate4sd3_1
X_2213_ net237 net257 VGND VGND VPWR VPWR _0548_ sky130_fd_sc_hd__nand2_1
XFILLER_38_112 VGND VGND VPWR VPWR sky130_fd_sc_hd__decap_3
X_2144_ net247 _1103_ _0504_ VGND VGND VPWR VPWR _0353_ sky130_fd_sc_hd__mux2_1
XFILLER_53_137 VGND VGND VPWR VPWR sky130_fd_sc_hd__decap_3
X_2075_ _0458_ _0462_ _0473_ VGND VGND VPWR VPWR _0474_ sky130_fd_sc_hd__and3b_1
XFILLER_38_156 VGND VGND VPWR VPWR sky130_fd_sc_hd__decap_3
XTAP_TAPCELL_ROW_36_368 VGND VPWR sky130_fd_sc_hd__tapvpwrvgnd_1
XPHY_EDGE_ROW_28_Left_91 VGND VGND VPWR VPWR sky130_fd_sc_hd__decap_3
XFILLER_26_329 VGND VGND VPWR VPWR sky130_fd_sc_hd__fill_2
X_1859_ _1391_ _1397_ VGND VGND VPWR VPWR _1403_ sky130_fd_sc_hd__xor2_1
X_1928_ _1458_ _1459_ _1469_ _1470_ VGND VGND VPWR VPWR _1472_ sky130_fd_sc_hd__or4_1
XPHY_EDGE_ROW_12_Left_75 VGND VGND VPWR VPWR sky130_fd_sc_hd__decap_3
X_2977_ net5 VGND VGND VPWR VPWR _0073_ sky130_fd_sc_hd__inv_2
XFILLER_39_47 VGND VGND VPWR VPWR sky130_fd_sc_hd__fill_1
XFILLER_55_57 VGND VGND VPWR VPWR sky130_fd_sc_hd__fill_1
XFILLER_55_35 VGND VGND VPWR VPWR sky130_fd_sc_hd__decap_3
XFILLER_55_24 VGND VGND VPWR VPWR sky130_fd_sc_hd__decap_3
XTAP_TAPCELL_ROW_27_313 VGND VPWR sky130_fd_sc_hd__tapvpwrvgnd_1
XFILLER_17_307 VGND VGND VPWR VPWR sky130_fd_sc_hd__fill_1
XFILLER_52_192 VGND VGND VPWR VPWR sky130_fd_sc_hd__decap_3
XFILLER_52_181 VGND VGND VPWR VPWR sky130_fd_sc_hd__decap_3
XFILLER_40_365 VGND VGND VPWR VPWR sky130_fd_sc_hd__decap_3
XFILLER_40_321 VGND VGND VPWR VPWR sky130_fd_sc_hd__decap_3
XFILLER_25_340 VGND VGND VPWR VPWR sky130_fd_sc_hd__decap_3
XFILLER_20_60 VGND VGND VPWR VPWR sky130_fd_sc_hd__fill_1
XFILLER_4_211 VGND VGND VPWR VPWR sky130_fd_sc_hd__decap_3
XTAP_TAPCELL_ROW_10_202 VGND VPWR sky130_fd_sc_hd__tapvpwrvgnd_1
Xsplit3 net20 VGND VGND VPWR VPWR net8 sky130_fd_sc_hd__buf_2
XFILLER_4_277 VGND VGND VPWR VPWR sky130_fd_sc_hd__decap_3
XFILLER_50_129 VGND VGND VPWR VPWR sky130_fd_sc_hd__decap_3
XFILLER_50_107 VGND VGND VPWR VPWR sky130_fd_sc_hd__decap_3
X_2900_ net5 VGND VGND VPWR VPWR _0181_ sky130_fd_sc_hd__inv_2
Xhold80 shift_in\[12\] VGND VGND VPWR VPWR net85 sky130_fd_sc_hd__dlygate4sd3_1
Xhold91 shift_in\[14\] VGND VGND VPWR VPWR net96 sky130_fd_sc_hd__dlygate4sd3_1
X_1713_ _1255_ _1256_ VGND VGND VPWR VPWR _1257_ sky130_fd_sc_hd__nor2_1
XFILLER_43_192 VGND VGND VPWR VPWR sky130_fd_sc_hd__decap_3
XTAP_TAPCELL_ROW_33_349 VGND VPWR sky130_fd_sc_hd__tapvpwrvgnd_1
XFILLER_31_343 VGND VGND VPWR VPWR sky130_fd_sc_hd__decap_3
X_2762_ my_divider.divisor_reg\[0\] _1002_ my_divider.remainder_reg\[0\] VGND VGND
+ VPWR VPWR _1030_ sky130_fd_sc_hd__a21oi_1
X_2831_ net5 VGND VGND VPWR VPWR _0112_ sky130_fd_sc_hd__inv_2
X_1644_ my_mul.x2\[5\] acc_reg\[5\] _1173_ _1174_ VGND VGND VPWR VPWR _1188_ sky130_fd_sc_hd__o2bb2a_1
X_1575_ _1117_ _1118_ VGND VGND VPWR VPWR _1119_ sky130_fd_sc_hd__nand2b_2
X_2693_ div_quotient\[5\] _0972_ _0974_ net35 VGND VGND VPWR VPWR _0275_ sky130_fd_sc_hd__a22o_1
X_2127_ net85 my_mul.x2\[12\] _0500_ VGND VGND VPWR VPWR _0203_ sky130_fd_sc_hd__mux2_1
Xrebuffer12 my_sum_sub.cm_exp\[2\] VGND VGND VPWR VPWR net17 sky130_fd_sc_hd__dlymetal6s2s_1
X_2058_ _1485_ _1462_ VGND VGND VPWR VPWR _0459_ sky130_fd_sc_hd__nand2b_1
XFILLER_34_192 VGND VGND VPWR VPWR sky130_fd_sc_hd__decap_3
XFILLER_34_170 VGND VGND VPWR VPWR sky130_fd_sc_hd__decap_3
XFILLER_25_16 VGND VGND VPWR VPWR sky130_fd_sc_hd__decap_3
XFILLER_22_365 VGND VGND VPWR VPWR sky130_fd_sc_hd__decap_3
XFILLER_57_273 VGND VGND VPWR VPWR sky130_fd_sc_hd__decap_3
XFILLER_32_129 VGND VGND VPWR VPWR sky130_fd_sc_hd__fill_1
XFILLER_40_195 VGND VGND VPWR VPWR sky130_fd_sc_hd__fill_1
XFILLER_9_325 VGND VGND VPWR VPWR sky130_fd_sc_hd__fill_2
XFILLER_9_369 VGND VGND VPWR VPWR sky130_fd_sc_hd__fill_1
XFILLER_48_284 VGND VGND VPWR VPWR sky130_fd_sc_hd__decap_3
XFILLER_48_251 VGND VGND VPWR VPWR sky130_fd_sc_hd__fill_1
X_3030_ clknet_4_11_0_clk net192 _0126_ VGND VGND VPWR VPWR my_sum_sub.result\[13\]
+ sky130_fd_sc_hd__dfrtp_1
X_2814_ net2 VGND VGND VPWR VPWR _0095_ sky130_fd_sc_hd__inv_2
X_2745_ acc_reg\[5\] _0364_ _0973_ VGND VGND VPWR VPWR _1017_ sky130_fd_sc_hd__and3_1
X_2676_ _0958_ _0961_ _0964_ net53 _1057_ VGND VGND VPWR VPWR _0281_ sky130_fd_sc_hd__a32o_1
X_1627_ my_mul.x2\[5\] acc_reg\[6\] _1157_ _1158_ VGND VGND VPWR VPWR _1171_ sky130_fd_sc_hd__o2bb2a_1
X_1558_ my_sum_sub.result\[15\] _1091_ _1102_ state\[4\] VGND VGND VPWR VPWR _1103_
+ sky130_fd_sc_hd__o211a_1
XFILLER_36_15 VGND VGND VPWR VPWR sky130_fd_sc_hd__decap_3
X_3159_ clknet_4_14_0_clk net282 _0070_ VGND VGND VPWR VPWR my_sum_sub.state\[1\]
+ sky130_fd_sc_hd__dfrtp_4
XFILLER_52_47 VGND VGND VPWR VPWR sky130_fd_sc_hd__decap_3
XFILLER_22_151 VGND VGND VPWR VPWR sky130_fd_sc_hd__fill_2
XFILLER_10_335 VGND VGND VPWR VPWR sky130_fd_sc_hd__decap_3
XFILLER_10_346 VGND VGND VPWR VPWR sky130_fd_sc_hd__decap_3
XFILLER_10_368 VGND VGND VPWR VPWR sky130_fd_sc_hd__fill_2
XFILLER_60_268 VGND VGND VPWR VPWR sky130_fd_sc_hd__decap_3
XFILLER_45_254 VGND VGND VPWR VPWR sky130_fd_sc_hd__decap_3
XFILLER_61_6 VGND VGND VPWR VPWR sky130_fd_sc_hd__decap_3
X_2530_ _0793_ _0808_ VGND VGND VPWR VPWR _0829_ sky130_fd_sc_hd__xor2_2
X_2392_ net103 _1055_ _0606_ acc_reg\[9\] VGND VGND VPWR VPWR _0694_ sky130_fd_sc_hd__a22o_1
X_2461_ _0738_ _0742_ VGND VGND VPWR VPWR _0760_ sky130_fd_sc_hd__nor2_1
XFILLER_51_213 VGND VGND VPWR VPWR sky130_fd_sc_hd__fill_1
XFILLER_3_96 VGND VGND VPWR VPWR sky130_fd_sc_hd__fill_1
X_3013_ clknet_4_3_0_clk net116 _0109_ VGND VGND VPWR VPWR div_quotient\[3\] sky130_fd_sc_hd__dfrtp_1
XFILLER_51_279 VGND VGND VPWR VPWR sky130_fd_sc_hd__fill_1
X_2728_ _0998_ _1000_ VGND VGND VPWR VPWR _1003_ sky130_fd_sc_hd__xnor2_1
X_2659_ _0943_ _0944_ _0957_ VGND VGND VPWR VPWR _0958_ sky130_fd_sc_hd__a21oi_4
XFILLER_59_346 VGND VGND VPWR VPWR sky130_fd_sc_hd__decap_3
XFILLER_59_335 VGND VGND VPWR VPWR sky130_fd_sc_hd__fill_1
XFILLER_59_302 VGND VGND VPWR VPWR sky130_fd_sc_hd__decap_3
XTAP_TAPCELL_ROW_57_503 VGND VPWR sky130_fd_sc_hd__tapvpwrvgnd_1
XFILLER_42_235 VGND VGND VPWR VPWR sky130_fd_sc_hd__fill_1
XFILLER_42_224 VGND VGND VPWR VPWR sky130_fd_sc_hd__decap_3
XFILLER_27_276 VGND VGND VPWR VPWR sky130_fd_sc_hd__decap_3
XFILLER_27_232 VGND VGND VPWR VPWR sky130_fd_sc_hd__fill_1
XFILLER_27_221 VGND VGND VPWR VPWR sky130_fd_sc_hd__decap_3
XFILLER_6_114 VGND VGND VPWR VPWR sky130_fd_sc_hd__decap_3
XFILLER_12_50 VGND VGND VPWR VPWR sky130_fd_sc_hd__fill_1
XPHY_EDGE_ROW_0_Left_63 VGND VGND VPWR VPWR sky130_fd_sc_hd__decap_3
XFILLER_26_9 VGND VGND VPWR VPWR sky130_fd_sc_hd__fill_2
XFILLER_18_243 VGND VGND VPWR VPWR sky130_fd_sc_hd__fill_2
XFILLER_18_276 VGND VGND VPWR VPWR sky130_fd_sc_hd__decap_3
X_1961_ _1461_ _1478_ _1485_ VGND VGND VPWR VPWR _0370_ sky130_fd_sc_hd__or3_1
X_1892_ _1136_ _1140_ VGND VGND VPWR VPWR _1436_ sky130_fd_sc_hd__and2_1
XFILLER_33_246 VGND VGND VPWR VPWR sky130_fd_sc_hd__decap_3
XFILLER_18_287 VGND VGND VPWR VPWR sky130_fd_sc_hd__decap_3
X_2513_ _0809_ _0810_ _0811_ VGND VGND VPWR VPWR _0812_ sky130_fd_sc_hd__a21oi_1
X_2375_ _0606_ _0651_ VGND VGND VPWR VPWR _0686_ sky130_fd_sc_hd__and2_1
X_2444_ my_sum_sub.cm_mant\[6\] _0730_ VGND VGND VPWR VPWR _0743_ sky130_fd_sc_hd__or2_2
XTAP_TAPCELL_ROW_19_260 VGND VPWR sky130_fd_sc_hd__tapvpwrvgnd_1
XFILLER_58_35 VGND VGND VPWR VPWR sky130_fd_sc_hd__decap_3
XFILLER_58_24 VGND VGND VPWR VPWR sky130_fd_sc_hd__decap_3
XFILLER_59_187 VGND VGND VPWR VPWR sky130_fd_sc_hd__decap_3
XFILLER_59_154 VGND VGND VPWR VPWR sky130_fd_sc_hd__decap_3
XFILLER_59_143 VGND VGND VPWR VPWR sky130_fd_sc_hd__decap_3
XFILLER_58_57 VGND VGND VPWR VPWR sky130_fd_sc_hd__decap_3
XFILLER_47_316 VGND VGND VPWR VPWR sky130_fd_sc_hd__decap_3
XTAP_TAPCELL_ROW_2_150 VGND VPWR sky130_fd_sc_hd__tapvpwrvgnd_1
XFILLER_30_216 VGND VGND VPWR VPWR sky130_fd_sc_hd__decap_3
XTAP_TAPCELL_ROW_25_296 VGND VPWR sky130_fd_sc_hd__tapvpwrvgnd_1
XFILLER_15_257 VGND VGND VPWR VPWR sky130_fd_sc_hd__decap_3
X_2160_ net307 _0491_ _0504_ VGND VGND VPWR VPWR _0339_ sky130_fd_sc_hd__mux2_1
XFILLER_61_352 VGND VGND VPWR VPWR sky130_fd_sc_hd__decap_3
X_2091_ net46 _1099_ _0486_ _0487_ VGND VGND VPWR VPWR _0225_ sky130_fd_sc_hd__o22a_1
XFILLER_0_53 VGND VGND VPWR VPWR sky130_fd_sc_hd__decap_3
XTAP_TAPCELL_ROW_16_241 VGND VPWR sky130_fd_sc_hd__tapvpwrvgnd_1
X_1875_ _1418_ VGND VGND VPWR VPWR _1419_ sky130_fd_sc_hd__inv_2
X_1944_ _1425_ _1447_ _1463_ _1487_ VGND VGND VPWR VPWR _1488_ sky130_fd_sc_hd__or4_1
XFILLER_21_249 VGND VGND VPWR VPWR sky130_fd_sc_hd__decap_3
X_2993_ clknet_4_8_0_clk net94 _0089_ VGND VGND VPWR VPWR my_divider.divisor_reg\[4\]
+ sky130_fd_sc_hd__dfrtp_1
X_2427_ net25 my_sum_sub.cm_mant\[8\] VGND VGND VPWR VPWR _0726_ sky130_fd_sc_hd__or2_1
XFILLER_0_109 VGND VGND VPWR VPWR sky130_fd_sc_hd__decap_3
XFILLER_56_179 VGND VGND VPWR VPWR sky130_fd_sc_hd__decap_3
XFILLER_56_157 VGND VGND VPWR VPWR sky130_fd_sc_hd__decap_3
Xclkbuf_4_15_0_clk clknet_0_clk VGND VGND VPWR VPWR clknet_4_15_0_clk sky130_fd_sc_hd__clkbuf_8
X_2358_ my_sum_sub.state\[2\] net142 _0674_ VGND VGND VPWR VPWR _0309_ sky130_fd_sc_hd__o21a_1
X_2289_ _0388_ _0601_ _0603_ VGND VGND VPWR VPWR _0612_ sky130_fd_sc_hd__a21o_1
XTAP_TAPCELL_ROW_39_388 VGND VPWR sky130_fd_sc_hd__tapvpwrvgnd_1
XFILLER_8_209 VGND VGND VPWR VPWR sky130_fd_sc_hd__decap_3
XFILLER_60_58 VGND VGND VPWR VPWR sky130_fd_sc_hd__decap_3
XTAP_TAPCELL_ROW_22_277 VGND VPWR sky130_fd_sc_hd__tapvpwrvgnd_1
XFILLER_62_116 VGND VGND VPWR VPWR sky130_fd_sc_hd__decap_3
XFILLER_55_190 VGND VGND VPWR VPWR sky130_fd_sc_hd__fill_2
XFILLER_47_179 VGND VGND VPWR VPWR sky130_fd_sc_hd__decap_3
XFILLER_7_231 VGND VGND VPWR VPWR sky130_fd_sc_hd__fill_1
XTAP_TAPCELL_ROW_13_222 VGND VPWR sky130_fd_sc_hd__tapvpwrvgnd_1
X_1660_ _1203_ VGND VGND VPWR VPWR _1204_ sky130_fd_sc_hd__inv_2
X_1591_ _1127_ _1134_ VGND VGND VPWR VPWR _1135_ sky130_fd_sc_hd__and2_1
XFILLER_7_275 VGND VGND VPWR VPWR sky130_fd_sc_hd__fill_1
Xhold209 my_divider.remainder_reg\[0\] VGND VGND VPWR VPWR net214 sky130_fd_sc_hd__dlygate4sd3_1
X_2212_ _1054_ _0545_ _0533_ VGND VGND VPWR VPWR _0547_ sky130_fd_sc_hd__mux2_1
XFILLER_53_105 VGND VGND VPWR VPWR sky130_fd_sc_hd__decap_3
XFILLER_38_168 VGND VGND VPWR VPWR sky130_fd_sc_hd__decap_3
XFILLER_22_3 VGND VGND VPWR VPWR sky130_fd_sc_hd__fill_2
X_2143_ _1095_ _0503_ VGND VGND VPWR VPWR _0504_ sky130_fd_sc_hd__nor2_8
XFILLER_61_160 VGND VGND VPWR VPWR sky130_fd_sc_hd__decap_3
XFILLER_53_116 VGND VGND VPWR VPWR sky130_fd_sc_hd__decap_3
X_2074_ _1477_ _0461_ VGND VGND VPWR VPWR _0473_ sky130_fd_sc_hd__nand2_1
XTAP_TAPCELL_ROW_36_369 VGND VPWR sky130_fd_sc_hd__tapvpwrvgnd_1
XFILLER_34_341 VGND VGND VPWR VPWR sky130_fd_sc_hd__decap_3
X_1858_ _1393_ _1394_ _1401_ VGND VGND VPWR VPWR _1402_ sky130_fd_sc_hd__a21o_1
X_1927_ _1469_ _1470_ VGND VGND VPWR VPWR _1471_ sky130_fd_sc_hd__or2_1
XFILLER_30_39 VGND VGND VPWR VPWR sky130_fd_sc_hd__decap_3
X_2976_ net2 VGND VGND VPWR VPWR _0072_ sky130_fd_sc_hd__inv_2
X_1789_ _1326_ _1332_ VGND VGND VPWR VPWR _1333_ sky130_fd_sc_hd__and2_1
XFILLER_55_47 VGND VGND VPWR VPWR sky130_fd_sc_hd__decap_3
XFILLER_37_190 VGND VGND VPWR VPWR sky130_fd_sc_hd__decap_3
XFILLER_29_124 VGND VGND VPWR VPWR sky130_fd_sc_hd__fill_2
XTAP_TAPCELL_ROW_10_203 VGND VPWR sky130_fd_sc_hd__tapvpwrvgnd_1
XFILLER_20_72 VGND VGND VPWR VPWR sky130_fd_sc_hd__fill_2
XFILLER_4_223 VGND VGND VPWR VPWR sky130_fd_sc_hd__fill_1
XFILLER_4_234 VGND VGND VPWR VPWR sky130_fd_sc_hd__decap_3
XFILLER_4_267 VGND VGND VPWR VPWR sky130_fd_sc_hd__fill_1
XFILLER_4_289 VGND VGND VPWR VPWR sky130_fd_sc_hd__decap_3
Xhold92 my_mul.x2\[10\] VGND VGND VPWR VPWR net97 sky130_fd_sc_hd__dlygate4sd3_1
Xhold81 _0203_ VGND VGND VPWR VPWR net86 sky130_fd_sc_hd__dlygate4sd3_1
Xhold70 _0251_ VGND VGND VPWR VPWR net75 sky130_fd_sc_hd__dlygate4sd3_1
XFILLER_31_333 VGND VGND VPWR VPWR sky130_fd_sc_hd__decap_3
X_2830_ net5 VGND VGND VPWR VPWR _0111_ sky130_fd_sc_hd__inv_2
XFILLER_16_352 VGND VGND VPWR VPWR sky130_fd_sc_hd__fill_1
XFILLER_16_363 VGND VGND VPWR VPWR sky130_fd_sc_hd__fill_1
X_1643_ _1178_ _1186_ VGND VGND VPWR VPWR _1187_ sky130_fd_sc_hd__nand2_1
X_1712_ _1231_ _1254_ VGND VGND VPWR VPWR _1256_ sky130_fd_sc_hd__and2_1
XFILLER_31_366 VGND VGND VPWR VPWR sky130_fd_sc_hd__decap_3
X_2761_ _0972_ _1027_ _1028_ _1029_ VGND VGND VPWR VPWR _0262_ sky130_fd_sc_hd__a31o_1
XFILLER_6_52 VGND VGND VPWR VPWR sky130_fd_sc_hd__fill_2
X_2692_ _0974_ VGND VGND VPWR VPWR my_divider.en_r sky130_fd_sc_hd__inv_2
XANTENNA_1 _0969_ VGND VGND VPWR VPWR sky130_fd_sc_hd__diode_2
XFILLER_58_208 VGND VGND VPWR VPWR sky130_fd_sc_hd__decap_3
X_1574_ acc_reg\[10\] my_mul.x2\[10\] VGND VGND VPWR VPWR _1118_ sky130_fd_sc_hd__nand2b_1
XFILLER_6_85 VGND VGND VPWR VPWR sky130_fd_sc_hd__fill_1
X_2057_ _0368_ _0379_ VGND VGND VPWR VPWR _0458_ sky130_fd_sc_hd__nand2_1
XFILLER_26_105 VGND VGND VPWR VPWR sky130_fd_sc_hd__decap_3
X_2126_ net95 net123 _0500_ VGND VGND VPWR VPWR _0204_ sky130_fd_sc_hd__mux2_1
Xrebuffer13 my_sum_sub.cm_exp\[4\] VGND VGND VPWR VPWR net18 sky130_fd_sc_hd__dlygate4sd3_1
XFILLER_22_333 VGND VGND VPWR VPWR sky130_fd_sc_hd__decap_3
X_2959_ net2 VGND VGND VPWR VPWR _0055_ sky130_fd_sc_hd__inv_2
XFILLER_57_252 VGND VGND VPWR VPWR sky130_fd_sc_hd__decap_3
XFILLER_57_296 VGND VGND VPWR VPWR sky130_fd_sc_hd__decap_3
XFILLER_25_193 VGND VGND VPWR VPWR sky130_fd_sc_hd__decap_3
XFILLER_17_116 VGND VGND VPWR VPWR sky130_fd_sc_hd__fill_1
XFILLER_13_366 VGND VGND VPWR VPWR sky130_fd_sc_hd__decap_3
XFILLER_56_9 VGND VGND VPWR VPWR sky130_fd_sc_hd__decap_3
XTAP_TAPCELL_ROW_46_431 VGND VPWR sky130_fd_sc_hd__tapvpwrvgnd_1
XFILLER_0_281 VGND VGND VPWR VPWR sky130_fd_sc_hd__decap_3
X_2813_ net2 VGND VGND VPWR VPWR _0094_ sky130_fd_sc_hd__inv_2
X_1626_ _1163_ _1164_ _1160_ VGND VGND VPWR VPWR _1170_ sky130_fd_sc_hd__o21ai_1
X_2744_ my_divider.remainder_reg\[4\] _1015_ _1002_ VGND VGND VPWR VPWR _1016_ sky130_fd_sc_hd__mux2_1
X_2675_ _0827_ _0852_ _0948_ _0963_ VGND VGND VPWR VPWR _0964_ sky130_fd_sc_hd__a31o_1
X_1557_ _1091_ _1101_ VGND VGND VPWR VPWR _1102_ sky130_fd_sc_hd__nand2_1
XFILLER_54_244 VGND VGND VPWR VPWR sky130_fd_sc_hd__decap_3
XFILLER_54_200 VGND VGND VPWR VPWR sky130_fd_sc_hd__decap_3
XFILLER_36_27 VGND VGND VPWR VPWR sky130_fd_sc_hd__fill_1
X_3089_ clknet_4_4_0_clk net267 _0185_ VGND VGND VPWR VPWR acc_reg\[10\] sky130_fd_sc_hd__dfrtp_2
X_2109_ net85 net91 net88 VGND VGND VPWR VPWR _0218_ sky130_fd_sc_hd__mux2_1
X_3158_ clknet_4_3_0_clk net160 _0069_ VGND VGND VPWR VPWR my_sum_sub.state\[0\] sky130_fd_sc_hd__dfstp_1
XFILLER_52_26 VGND VGND VPWR VPWR sky130_fd_sc_hd__fill_2
XFILLER_22_141 VGND VGND VPWR VPWR sky130_fd_sc_hd__fill_2
XFILLER_6_307 VGND VGND VPWR VPWR sky130_fd_sc_hd__fill_1
XFILLER_6_318 VGND VGND VPWR VPWR sky130_fd_sc_hd__decap_3
XFILLER_10_314 VGND VGND VPWR VPWR sky130_fd_sc_hd__decap_3
XFILLER_45_233 VGND VGND VPWR VPWR sky130_fd_sc_hd__decap_3
XFILLER_45_222 VGND VGND VPWR VPWR sky130_fd_sc_hd__fill_2
XFILLER_45_211 VGND VGND VPWR VPWR sky130_fd_sc_hd__decap_3
XFILLER_60_203 VGND VGND VPWR VPWR sky130_fd_sc_hd__fill_2
XTAP_TAPCELL_ROW_43_412 VGND VPWR sky130_fd_sc_hd__tapvpwrvgnd_1
XFILLER_13_141 VGND VGND VPWR VPWR sky130_fd_sc_hd__fill_2
XFILLER_54_6 VGND VGND VPWR VPWR sky130_fd_sc_hd__decap_3
XFILLER_5_340 VGND VGND VPWR VPWR sky130_fd_sc_hd__decap_3
XFILLER_9_167 VGND VGND VPWR VPWR sky130_fd_sc_hd__fill_1
XFILLER_13_196 VGND VGND VPWR VPWR sky130_fd_sc_hd__fill_2
Xrebuffer4 _0880_ VGND VGND VPWR VPWR net9 sky130_fd_sc_hd__dlygate4sd3_1
X_2460_ _0757_ _0758_ VGND VGND VPWR VPWR _0759_ sky130_fd_sc_hd__nand2_2
X_2391_ net98 _1055_ _0607_ net97 _0693_ VGND VGND VPWR VPWR _0295_ sky130_fd_sc_hd__a221o_1
XFILLER_51_225 VGND VGND VPWR VPWR sky130_fd_sc_hd__decap_3
XFILLER_36_222 VGND VGND VPWR VPWR sky130_fd_sc_hd__decap_3
XFILLER_36_200 VGND VGND VPWR VPWR sky130_fd_sc_hd__decap_3
X_3012_ clknet_4_2_0_clk _0271_ _0108_ VGND VGND VPWR VPWR div_quotient\[2\] sky130_fd_sc_hd__dfrtp_1
XFILLER_22_29 VGND VGND VPWR VPWR sky130_fd_sc_hd__fill_1
X_1609_ my_mul.x2\[7\] acc_reg\[7\] VGND VGND VPWR VPWR _1153_ sky130_fd_sc_hd__xnor2_4
X_2727_ net196 _0974_ _1002_ _0972_ VGND VGND VPWR VPWR _0269_ sky130_fd_sc_hd__a22o_1
X_2589_ _0885_ _0887_ VGND VGND VPWR VPWR _0888_ sky130_fd_sc_hd__nor2_1
X_2658_ _0904_ _0950_ _0956_ VGND VGND VPWR VPWR _0957_ sky130_fd_sc_hd__a21o_1
XFILLER_59_358 VGND VGND VPWR VPWR sky130_fd_sc_hd__decap_3
XFILLER_59_314 VGND VGND VPWR VPWR sky130_fd_sc_hd__decap_3
XTAP_TAPCELL_ROW_57_504 VGND VPWR sky130_fd_sc_hd__tapvpwrvgnd_1
XFILLER_47_37 VGND VGND VPWR VPWR sky130_fd_sc_hd__decap_3
XFILLER_42_247 VGND VGND VPWR VPWR sky130_fd_sc_hd__decap_3
XFILLER_33_225 VGND VGND VPWR VPWR sky130_fd_sc_hd__decap_3
XTAP_TAPCELL_ROW_5_170 VGND VPWR sky130_fd_sc_hd__tapvpwrvgnd_1
XFILLER_53_91 VGND VGND VPWR VPWR sky130_fd_sc_hd__fill_2
X_1960_ _0368_ VGND VGND VPWR VPWR _0369_ sky130_fd_sc_hd__inv_2
X_1891_ _1116_ _1433_ VGND VGND VPWR VPWR _1435_ sky130_fd_sc_hd__xor2_1
XFILLER_52_3 VGND VGND VPWR VPWR sky130_fd_sc_hd__fill_1
X_2443_ my_sum_sub.cm_mant\[6\] _0730_ VGND VGND VPWR VPWR _0742_ sky130_fd_sc_hd__nor2_1
X_2512_ _0800_ _0802_ _0804_ VGND VGND VPWR VPWR _0811_ sky130_fd_sc_hd__nor3b_1
X_2374_ _1055_ net209 _0648_ _0682_ _0685_ VGND VGND VPWR VPWR _0304_ sky130_fd_sc_hd__a221o_1
XTAP_TAPCELL_ROW_62_540 VGND VPWR sky130_fd_sc_hd__tapvpwrvgnd_1
XFILLER_24_247 VGND VGND VPWR VPWR sky130_fd_sc_hd__decap_3
XFILLER_24_225 VGND VGND VPWR VPWR sky130_fd_sc_hd__decap_3
XTAP_TAPCELL_ROW_19_261 VGND VPWR sky130_fd_sc_hd__tapvpwrvgnd_1
XFILLER_59_100 VGND VGND VPWR VPWR sky130_fd_sc_hd__fill_2
XFILLER_62_309 VGND VGND VPWR VPWR sky130_fd_sc_hd__decap_3
XFILLER_59_199 VGND VGND VPWR VPWR sky130_fd_sc_hd__decap_3
XFILLER_59_166 VGND VGND VPWR VPWR sky130_fd_sc_hd__fill_2
XFILLER_47_328 VGND VGND VPWR VPWR sky130_fd_sc_hd__fill_2
XTAP_TAPCELL_ROW_2_151 VGND VPWR sky130_fd_sc_hd__tapvpwrvgnd_1
XFILLER_15_225 VGND VGND VPWR VPWR sky130_fd_sc_hd__fill_1
XFILLER_30_228 VGND VGND VPWR VPWR sky130_fd_sc_hd__fill_2
XFILLER_30_206 VGND VGND VPWR VPWR sky130_fd_sc_hd__decap_3
XTAP_TAPCELL_ROW_25_297 VGND VPWR sky130_fd_sc_hd__tapvpwrvgnd_1
XFILLER_15_269 VGND VGND VPWR VPWR sky130_fd_sc_hd__fill_1
X_2090_ shift_out\[3\] _1064_ _1097_ acc_reg\[2\] _1100_ VGND VGND VPWR VPWR _0487_
+ sky130_fd_sc_hd__a221o_1
XFILLER_17_6 VGND VGND VPWR VPWR sky130_fd_sc_hd__decap_3
XFILLER_61_364 VGND VGND VPWR VPWR sky130_fd_sc_hd__decap_3
XFILLER_61_320 VGND VGND VPWR VPWR sky130_fd_sc_hd__decap_3
XFILLER_53_309 VGND VGND VPWR VPWR sky130_fd_sc_hd__decap_3
XFILLER_46_361 VGND VGND VPWR VPWR sky130_fd_sc_hd__decap_3
X_2992_ clknet_4_2_0_clk net75 _0088_ VGND VGND VPWR VPWR my_divider.divisor_reg\[3\]
+ sky130_fd_sc_hd__dfrtp_1
XTAP_TAPCELL_ROW_16_242 VGND VPWR sky130_fd_sc_hd__tapvpwrvgnd_1
X_1874_ _1169_ _1417_ VGND VGND VPWR VPWR _1418_ sky130_fd_sc_hd__xnor2_1
X_1943_ _1467_ _1472_ _1478_ _1486_ VGND VGND VPWR VPWR _1487_ sky130_fd_sc_hd__or4_1
XFILLER_14_280 VGND VGND VPWR VPWR sky130_fd_sc_hd__decap_3
X_2426_ _0721_ _0724_ _0720_ VGND VGND VPWR VPWR _0725_ sky130_fd_sc_hd__or3b_4
XFILLER_56_169 VGND VGND VPWR VPWR sky130_fd_sc_hd__fill_2
XFILLER_56_114 VGND VGND VPWR VPWR sky130_fd_sc_hd__decap_3
XFILLER_52_320 VGND VGND VPWR VPWR sky130_fd_sc_hd__decap_3
X_2357_ _0604_ _0668_ _0673_ _0616_ _1055_ VGND VGND VPWR VPWR _0674_ sky130_fd_sc_hd__a221o_1
XTAP_TAPCELL_ROW_39_389 VGND VPWR sky130_fd_sc_hd__tapvpwrvgnd_1
X_2288_ _0601_ _0609_ _0610_ _0400_ _0604_ VGND VGND VPWR VPWR _0611_ sky130_fd_sc_hd__a221oi_2
XFILLER_60_15 VGND VGND VPWR VPWR sky130_fd_sc_hd__decap_3
XFILLER_52_342 VGND VGND VPWR VPWR sky130_fd_sc_hd__fill_1
XFILLER_12_206 VGND VGND VPWR VPWR sky130_fd_sc_hd__fill_2
XFILLER_12_228 VGND VGND VPWR VPWR sky130_fd_sc_hd__fill_2
XFILLER_60_48 VGND VGND VPWR VPWR sky130_fd_sc_hd__fill_1
XTAP_TAPCELL_ROW_22_278 VGND VPWR sky130_fd_sc_hd__tapvpwrvgnd_1
XFILLER_47_103 VGND VGND VPWR VPWR sky130_fd_sc_hd__decap_3
XFILLER_62_106 VGND VGND VPWR VPWR sky130_fd_sc_hd__decap_3
XFILLER_11_250 VGND VGND VPWR VPWR sky130_fd_sc_hd__decap_3
XFILLER_50_70 VGND VGND VPWR VPWR sky130_fd_sc_hd__decap_3
X_1590_ _1132_ _1133_ VGND VGND VPWR VPWR _1134_ sky130_fd_sc_hd__nor2_1
XFILLER_53_128 VGND VGND VPWR VPWR sky130_fd_sc_hd__decap_3
XFILLER_38_147 VGND VGND VPWR VPWR sky130_fd_sc_hd__decap_3
XFILLER_38_103 VGND VGND VPWR VPWR sky130_fd_sc_hd__decap_3
X_2073_ net60 _1099_ _0471_ _0472_ VGND VGND VPWR VPWR _0228_ sky130_fd_sc_hd__o22a_1
X_2211_ my_sum_sub.al_sb_eff my_sum_sub.al_sa VGND VGND VPWR VPWR _0546_ sky130_fd_sc_hd__xor2_4
X_2142_ net284 _0501_ _0502_ _1087_ ss_s1 VGND VGND VPWR VPWR _0503_ sky130_fd_sc_hd__a2111o_2
XFILLER_15_3 VGND VGND VPWR VPWR sky130_fd_sc_hd__decap_3
XPHY_EDGE_ROW_46_Left_109 VGND VGND VPWR VPWR sky130_fd_sc_hd__decap_3
X_2975_ net5 VGND VGND VPWR VPWR _0071_ sky130_fd_sc_hd__inv_2
X_1788_ _1327_ _1331_ VGND VGND VPWR VPWR _1332_ sky130_fd_sc_hd__xnor2_1
XPHY_EDGE_ROW_55_Left_118 VGND VGND VPWR VPWR sky130_fd_sc_hd__decap_3
X_1857_ acc_reg\[2\] _1363_ _1396_ _1400_ VGND VGND VPWR VPWR _1401_ sky130_fd_sc_hd__a211o_1
X_1926_ _1183_ _1420_ _1468_ VGND VGND VPWR VPWR _1470_ sky130_fd_sc_hd__and3_1
XFILLER_30_29 VGND VGND VPWR VPWR sky130_fd_sc_hd__fill_1
X_2409_ _0706_ _0707_ VGND VGND VPWR VPWR _0708_ sky130_fd_sc_hd__or2_1
XFILLER_55_15 VGND VGND VPWR VPWR sky130_fd_sc_hd__decap_3
XFILLER_52_161 VGND VGND VPWR VPWR sky130_fd_sc_hd__decap_3
XFILLER_44_139 VGND VGND VPWR VPWR sky130_fd_sc_hd__fill_1
XFILLER_40_301 VGND VGND VPWR VPWR sky130_fd_sc_hd__decap_3
XFILLER_40_312 VGND VGND VPWR VPWR sky130_fd_sc_hd__decap_3
XFILLER_20_51 VGND VGND VPWR VPWR sky130_fd_sc_hd__fill_1
XFILLER_4_202 VGND VGND VPWR VPWR sky130_fd_sc_hd__decap_3
XFILLER_4_246 VGND VGND VPWR VPWR sky130_fd_sc_hd__decap_3
Xhold93 my_sum_sub.al_exp\[3\] VGND VGND VPWR VPWR net98 sky130_fd_sc_hd__dlygate4sd3_1
Xhold71 shift_out\[12\] VGND VGND VPWR VPWR net76 sky130_fd_sc_hd__dlygate4sd3_1
Xhold60 _0236_ VGND VGND VPWR VPWR net65 sky130_fd_sc_hd__dlygate4sd3_1
Xhold82 sclk_s1 VGND VGND VPWR VPWR net87 sky130_fd_sc_hd__dlygate4sd3_1
X_1642_ my_mul.x2\[4\] _1177_ VGND VGND VPWR VPWR _1186_ sky130_fd_sc_hd__or2_1
X_1711_ _1231_ _1254_ VGND VGND VPWR VPWR _1255_ sky130_fd_sc_hd__nor2_1
Xclkbuf_4_14_0_clk clknet_0_clk VGND VGND VPWR VPWR clknet_4_14_0_clk sky130_fd_sc_hd__clkbuf_8
X_2760_ _0658_ _0973_ _0974_ net288 VGND VGND VPWR VPWR _1029_ sky130_fd_sc_hd__a22o_1
X_2691_ _0972_ _0973_ VGND VGND VPWR VPWR _0974_ sky130_fd_sc_hd__nor2_4
XANTENNA_2 _0970_ VGND VGND VPWR VPWR sky130_fd_sc_hd__diode_2
X_1573_ my_mul.x2\[10\] acc_reg\[10\] VGND VGND VPWR VPWR _1117_ sky130_fd_sc_hd__and2b_1
XTAP_TAPCELL_ROW_49_451 VGND VPWR sky130_fd_sc_hd__tapvpwrvgnd_1
X_2056_ net51 _1099_ _0456_ _0457_ VGND VGND VPWR VPWR _0230_ sky130_fd_sc_hd__o22a_1
XFILLER_34_161 VGND VGND VPWR VPWR sky130_fd_sc_hd__decap_3
XFILLER_34_150 VGND VGND VPWR VPWR sky130_fd_sc_hd__decap_3
X_2125_ net96 net100 _0500_ VGND VGND VPWR VPWR _0205_ sky130_fd_sc_hd__mux2_1
Xrebuffer14 net18 VGND VGND VPWR VPWR net19 sky130_fd_sc_hd__dlygate4sd1_1
X_1909_ _1183_ _1404_ _1420_ _1452_ VGND VGND VPWR VPWR _1453_ sky130_fd_sc_hd__and4_1
XTAP_TAPCELL_ROW_32_340 VGND VPWR sky130_fd_sc_hd__tapvpwrvgnd_1
XFILLER_22_323 VGND VGND VPWR VPWR sky130_fd_sc_hd__fill_2
X_2958_ net2 VGND VGND VPWR VPWR _0054_ sky130_fd_sc_hd__inv_2
X_2889_ net2 VGND VGND VPWR VPWR _0170_ sky130_fd_sc_hd__inv_2
XFILLER_57_264 VGND VGND VPWR VPWR sky130_fd_sc_hd__decap_3
XFILLER_57_220 VGND VGND VPWR VPWR sky130_fd_sc_hd__decap_3
XFILLER_25_172 VGND VGND VPWR VPWR sky130_fd_sc_hd__decap_3
XFILLER_40_197 VGND VGND VPWR VPWR sky130_fd_sc_hd__decap_3
XFILLER_40_164 VGND VGND VPWR VPWR sky130_fd_sc_hd__decap_3
XFILLER_49_9 VGND VGND VPWR VPWR sky130_fd_sc_hd__decap_3
Xoutput4 net4 VGND VGND VPWR VPWR miso sky130_fd_sc_hd__buf_8
XFILLER_56_80 VGND VGND VPWR VPWR sky130_fd_sc_hd__decap_3
XFILLER_48_220 VGND VGND VPWR VPWR sky130_fd_sc_hd__decap_3
XTAP_TAPCELL_ROW_46_432 VGND VPWR sky130_fd_sc_hd__tapvpwrvgnd_1
XFILLER_0_293 VGND VGND VPWR VPWR sky130_fd_sc_hd__decap_3
XFILLER_31_153 VGND VGND VPWR VPWR sky130_fd_sc_hd__fill_2
X_2812_ net2 VGND VGND VPWR VPWR _0093_ sky130_fd_sc_hd__inv_2
X_2743_ _0995_ _1014_ VGND VGND VPWR VPWR _1015_ sky130_fd_sc_hd__nor2_1
X_1625_ _1168_ VGND VGND VPWR VPWR _1169_ sky130_fd_sc_hd__inv_2
X_1556_ net156 net247 VGND VGND VPWR VPWR _1101_ sky130_fd_sc_hd__xnor2_1
X_2674_ _0769_ _0900_ _0897_ _0828_ VGND VGND VPWR VPWR _0963_ sky130_fd_sc_hd__o211a_1
XFILLER_39_231 VGND VGND VPWR VPWR sky130_fd_sc_hd__decap_3
X_3157_ clknet_4_0_0_clk _0010_ _0068_ VGND VGND VPWR VPWR state\[5\] sky130_fd_sc_hd__dfrtp_1
XFILLER_54_267 VGND VGND VPWR VPWR sky130_fd_sc_hd__decap_3
XFILLER_54_256 VGND VGND VPWR VPWR sky130_fd_sc_hd__decap_3
XFILLER_54_223 VGND VGND VPWR VPWR sky130_fd_sc_hd__decap_3
X_2039_ _1088_ _0407_ _0442_ _1090_ VGND VGND VPWR VPWR _0443_ sky130_fd_sc_hd__a31o_1
X_3088_ clknet_4_5_0_clk _0347_ _0184_ VGND VGND VPWR VPWR acc_reg\[9\] sky130_fd_sc_hd__dfrtp_4
X_2108_ net95 net85 net88 VGND VGND VPWR VPWR _0219_ sky130_fd_sc_hd__mux2_1
XFILLER_22_131 VGND VGND VPWR VPWR sky130_fd_sc_hd__fill_1
XFILLER_10_304 VGND VGND VPWR VPWR sky130_fd_sc_hd__decap_3
XFILLER_10_326 VGND VGND VPWR VPWR sky130_fd_sc_hd__decap_3
XFILLER_45_245 VGND VGND VPWR VPWR sky130_fd_sc_hd__decap_3
XFILLER_26_50 VGND VGND VPWR VPWR sky130_fd_sc_hd__decap_3
XFILLER_60_259 VGND VGND VPWR VPWR sky130_fd_sc_hd__decap_3
XFILLER_60_248 VGND VGND VPWR VPWR sky130_fd_sc_hd__decap_3
XFILLER_45_289 VGND VGND VPWR VPWR sky130_fd_sc_hd__decap_3
XTAP_TAPCELL_ROW_43_413 VGND VPWR sky130_fd_sc_hd__tapvpwrvgnd_1
XFILLER_47_6 VGND VGND VPWR VPWR sky130_fd_sc_hd__fill_1
XFILLER_42_82 VGND VGND VPWR VPWR sky130_fd_sc_hd__fill_2
Xrebuffer5 my_sum_sub.cm_exp\[3\] VGND VGND VPWR VPWR net10 sky130_fd_sc_hd__dlygate4sd1_1
X_2390_ acc_reg\[10\] _0606_ VGND VGND VPWR VPWR _0693_ sky130_fd_sc_hd__and2_1
XFILLER_3_54 VGND VGND VPWR VPWR sky130_fd_sc_hd__fill_2
XTAP_TAPCELL_ROW_8_190 VGND VPWR sky130_fd_sc_hd__tapvpwrvgnd_1
X_3011_ clknet_4_2_0_clk net164 _0107_ VGND VGND VPWR VPWR div_quotient\[1\] sky130_fd_sc_hd__dfrtp_1
XFILLER_51_237 VGND VGND VPWR VPWR sky130_fd_sc_hd__decap_3
XFILLER_36_234 VGND VGND VPWR VPWR sky130_fd_sc_hd__decap_3
X_2726_ net245 _1001_ VGND VGND VPWR VPWR _1002_ sky130_fd_sc_hd__xor2_4
XFILLER_59_337 VGND VGND VPWR VPWR sky130_fd_sc_hd__decap_3
XFILLER_59_326 VGND VGND VPWR VPWR sky130_fd_sc_hd__decap_3
X_1608_ _1143_ _1151_ VGND VGND VPWR VPWR _1152_ sky130_fd_sc_hd__or2_2
X_2588_ _0859_ _0886_ VGND VGND VPWR VPWR _0887_ sky130_fd_sc_hd__nand2_1
X_2657_ _0850_ _0866_ _0955_ VGND VGND VPWR VPWR _0956_ sky130_fd_sc_hd__o21ai_1
X_1539_ my_sum_sub.operation op_reg\[2\] op_reg\[1\] op_reg\[0\] VGND VGND VPWR VPWR
+ _1084_ sky130_fd_sc_hd__or4b_4
XTAP_TAPCELL_ROW_57_505 VGND VPWR sky130_fd_sc_hd__tapvpwrvgnd_1
XFILLER_42_215 VGND VGND VPWR VPWR sky130_fd_sc_hd__decap_3
XFILLER_10_101 VGND VGND VPWR VPWR sky130_fd_sc_hd__decap_3
XFILLER_6_138 VGND VGND VPWR VPWR sky130_fd_sc_hd__fill_2
XFILLER_12_74 VGND VGND VPWR VPWR sky130_fd_sc_hd__fill_2
XFILLER_12_85 VGND VGND VPWR VPWR sky130_fd_sc_hd__decap_3
Xhold190 _0263_ VGND VGND VPWR VPWR net195 sky130_fd_sc_hd__dlygate4sd3_1
XFILLER_33_237 VGND VGND VPWR VPWR sky130_fd_sc_hd__decap_3
XFILLER_33_215 VGND VGND VPWR VPWR sky130_fd_sc_hd__decap_3
XPHY_EDGE_ROW_16_Right_16 VGND VGND VPWR VPWR sky130_fd_sc_hd__decap_3
XFILLER_18_212 VGND VGND VPWR VPWR sky130_fd_sc_hd__fill_1
XFILLER_53_70 VGND VGND VPWR VPWR sky130_fd_sc_hd__decap_3
X_1890_ _1116_ _1433_ VGND VGND VPWR VPWR _1434_ sky130_fd_sc_hd__xnor2_1
XPHY_EDGE_ROW_25_Right_25 VGND VGND VPWR VPWR sky130_fd_sc_hd__decap_3
X_2373_ acc_reg\[4\] _0364_ _0606_ VGND VGND VPWR VPWR _0685_ sky130_fd_sc_hd__and3_1
XFILLER_45_3 VGND VGND VPWR VPWR sky130_fd_sc_hd__decap_3
X_2442_ net8 my_sum_sub.cm_mant\[6\] VGND VGND VPWR VPWR _0741_ sky130_fd_sc_hd__nor2_1
X_2511_ _0775_ _0792_ VGND VGND VPWR VPWR _0810_ sky130_fd_sc_hd__xnor2_1
XFILLER_56_307 VGND VGND VPWR VPWR sky130_fd_sc_hd__fill_1
XPHY_EDGE_ROW_34_Right_34 VGND VGND VPWR VPWR sky130_fd_sc_hd__decap_3
XTAP_TAPCELL_ROW_62_541 VGND VPWR sky130_fd_sc_hd__tapvpwrvgnd_1
XFILLER_24_237 VGND VGND VPWR VPWR sky130_fd_sc_hd__fill_1
XPHY_EDGE_ROW_43_Right_43 VGND VGND VPWR VPWR sky130_fd_sc_hd__decap_3
XFILLER_3_108 VGND VGND VPWR VPWR sky130_fd_sc_hd__decap_3
X_2709_ _0983_ _0984_ VGND VGND VPWR VPWR _0985_ sky130_fd_sc_hd__nor2_1
XFILLER_59_178 VGND VGND VPWR VPWR sky130_fd_sc_hd__decap_3
XFILLER_59_123 VGND VGND VPWR VPWR sky130_fd_sc_hd__decap_3
XFILLER_58_48 VGND VGND VPWR VPWR sky130_fd_sc_hd__fill_2
XFILLER_58_15 VGND VGND VPWR VPWR sky130_fd_sc_hd__decap_3
XPHY_EDGE_ROW_52_Right_52 VGND VGND VPWR VPWR sky130_fd_sc_hd__decap_3
XFILLER_15_215 VGND VGND VPWR VPWR sky130_fd_sc_hd__fill_2
XPHY_EDGE_ROW_61_Right_61 VGND VGND VPWR VPWR sky130_fd_sc_hd__decap_3
XTAP_TAPCELL_ROW_25_298 VGND VPWR sky130_fd_sc_hd__tapvpwrvgnd_1
XFILLER_23_281 VGND VGND VPWR VPWR sky130_fd_sc_hd__fill_2
XFILLER_2_163 VGND VGND VPWR VPWR sky130_fd_sc_hd__decap_3
XFILLER_48_81 VGND VGND VPWR VPWR sky130_fd_sc_hd__decap_3
XFILLER_46_340 VGND VGND VPWR VPWR sky130_fd_sc_hd__decap_3
XFILLER_2_185 VGND VGND VPWR VPWR sky130_fd_sc_hd__decap_3
XFILLER_61_343 VGND VGND VPWR VPWR sky130_fd_sc_hd__decap_3
XFILLER_61_332 VGND VGND VPWR VPWR sky130_fd_sc_hd__decap_3
X_1942_ _1479_ _1480_ _1483_ _1484_ VGND VGND VPWR VPWR _1486_ sky130_fd_sc_hd__or4_1
X_2991_ clknet_4_10_0_clk net71 _0087_ VGND VGND VPWR VPWR my_divider.divisor_reg\[2\]
+ sky130_fd_sc_hd__dfrtp_1
XFILLER_0_66 VGND VGND VPWR VPWR sky130_fd_sc_hd__fill_1
X_1873_ _1181_ _1206_ VGND VGND VPWR VPWR _1417_ sky130_fd_sc_hd__and2b_1
X_2356_ _0641_ _0672_ _0618_ VGND VGND VPWR VPWR _0673_ sky130_fd_sc_hd__mux2_1
X_2425_ _0706_ _0707_ _0723_ VGND VGND VPWR VPWR _0724_ sky130_fd_sc_hd__or3_1
XFILLER_56_148 VGND VGND VPWR VPWR sky130_fd_sc_hd__decap_3
XFILLER_56_126 VGND VGND VPWR VPWR sky130_fd_sc_hd__fill_2
XFILLER_37_340 VGND VGND VPWR VPWR sky130_fd_sc_hd__decap_3
X_2287_ _0399_ _0393_ _1137_ VGND VGND VPWR VPWR _0610_ sky130_fd_sc_hd__or3b_1
XTAP_TAPCELL_ROW_22_279 VGND VPWR sky130_fd_sc_hd__tapvpwrvgnd_1
XFILLER_18_40 VGND VGND VPWR VPWR sky130_fd_sc_hd__fill_1
XFILLER_55_181 VGND VGND VPWR VPWR sky130_fd_sc_hd__decap_3
XFILLER_43_321 VGND VGND VPWR VPWR sky130_fd_sc_hd__decap_3
XFILLER_50_82 VGND VGND VPWR VPWR sky130_fd_sc_hd__fill_2
XFILLER_50_60 VGND VGND VPWR VPWR sky130_fd_sc_hd__fill_2
XFILLER_7_200 VGND VGND VPWR VPWR sky130_fd_sc_hd__fill_1
XFILLER_11_273 VGND VGND VPWR VPWR sky130_fd_sc_hd__decap_3
XFILLER_11_284 VGND VGND VPWR VPWR sky130_fd_sc_hd__fill_1
X_2210_ _0540_ _0542_ _0543_ _0544_ my_sum_sub.al_b_larger VGND VGND VPWR VPWR _0545_
+ sky130_fd_sc_hd__a41o_1
XFILLER_46_181 VGND VGND VPWR VPWR sky130_fd_sc_hd__decap_3
X_2072_ shift_out\[6\] _1064_ _1097_ acc_reg\[5\] _1100_ VGND VGND VPWR VPWR _0472_
+ sky130_fd_sc_hd__a221o_1
XFILLER_34_332 VGND VGND VPWR VPWR sky130_fd_sc_hd__decap_3
X_2141_ state\[2\] state\[4\] VGND VGND VPWR VPWR _0502_ sky130_fd_sc_hd__nor2_1
XFILLER_61_195 VGND VGND VPWR VPWR sky130_fd_sc_hd__decap_3
XFILLER_61_140 VGND VGND VPWR VPWR sky130_fd_sc_hd__decap_3
X_1925_ _1183_ _1420_ _1465_ VGND VGND VPWR VPWR _1469_ sky130_fd_sc_hd__a21oi_1
X_2974_ net2 VGND VGND VPWR VPWR _0070_ sky130_fd_sc_hd__inv_2
X_1787_ _1328_ _1329_ VGND VGND VPWR VPWR _1331_ sky130_fd_sc_hd__xnor2_1
X_1856_ my_mul.x2\[1\] my_mul.x2\[0\] acc_reg\[1\] acc_reg\[0\] VGND VGND VPWR VPWR
+ _1400_ sky130_fd_sc_hd__nand4_1
X_2339_ my_sum_sub.state\[2\] net154 _0657_ VGND VGND VPWR VPWR _0311_ sky130_fd_sc_hd__o21a_1
X_2408_ my_sum_sub.cm_mant\[8\] _0702_ _0703_ _0700_ _0701_ VGND VGND VPWR VPWR _0707_
+ sky130_fd_sc_hd__a32o_2
XPHY_EDGE_ROW_2_Right_2 VGND VGND VPWR VPWR sky130_fd_sc_hd__decap_3
XFILLER_55_38 VGND VGND VPWR VPWR sky130_fd_sc_hd__decap_3
XFILLER_55_27 VGND VGND VPWR VPWR sky130_fd_sc_hd__fill_1
XFILLER_52_195 VGND VGND VPWR VPWR sky130_fd_sc_hd__fill_1
XFILLER_52_184 VGND VGND VPWR VPWR sky130_fd_sc_hd__fill_1
XFILLER_40_324 VGND VGND VPWR VPWR sky130_fd_sc_hd__fill_2
XFILLER_37_181 VGND VGND VPWR VPWR sky130_fd_sc_hd__decap_3
XTAP_TAPCELL_ROW_35_360 VGND VPWR sky130_fd_sc_hd__tapvpwrvgnd_1
XFILLER_25_321 VGND VGND VPWR VPWR sky130_fd_sc_hd__fill_2
XFILLER_40_368 VGND VGND VPWR VPWR sky130_fd_sc_hd__fill_2
XFILLER_4_214 VGND VGND VPWR VPWR sky130_fd_sc_hd__decap_3
Xhold50 _0226_ VGND VGND VPWR VPWR net55 sky130_fd_sc_hd__dlygate4sd3_1
Xhold61 shift_out\[9\] VGND VGND VPWR VPWR net66 sky130_fd_sc_hd__dlygate4sd3_1
Xhold94 _0295_ VGND VGND VPWR VPWR net99 sky130_fd_sc_hd__dlygate4sd3_1
XFILLER_29_83 VGND VGND VPWR VPWR sky130_fd_sc_hd__fill_1
Xhold72 _0235_ VGND VGND VPWR VPWR net77 sky130_fd_sc_hd__dlygate4sd3_1
Xhold83 _0498_ VGND VGND VPWR VPWR net88 sky130_fd_sc_hd__dlygate4sd3_1
XFILLER_16_321 VGND VGND VPWR VPWR sky130_fd_sc_hd__decap_3
XFILLER_45_60 VGND VGND VPWR VPWR sky130_fd_sc_hd__decap_3
XFILLER_43_195 VGND VGND VPWR VPWR sky130_fd_sc_hd__decap_3
XFILLER_31_346 VGND VGND VPWR VPWR sky130_fd_sc_hd__decap_3
XFILLER_16_365 VGND VGND VPWR VPWR sky130_fd_sc_hd__decap_3
XFILLER_61_81 VGND VGND VPWR VPWR sky130_fd_sc_hd__fill_1
X_1710_ _1249_ _1253_ _1232_ VGND VGND VPWR VPWR _1254_ sky130_fd_sc_hd__o21ai_1
X_1641_ _1181_ _1184_ VGND VGND VPWR VPWR _1185_ sky130_fd_sc_hd__nor2_1
X_1572_ _1113_ _1115_ VGND VGND VPWR VPWR _1116_ sky130_fd_sc_hd__or2_1
X_2690_ net168 net314 VGND VGND VPWR VPWR _0973_ sky130_fd_sc_hd__and2b_4
XFILLER_6_65 VGND VGND VPWR VPWR sky130_fd_sc_hd__decap_3
XANTENNA_3 _0971_ VGND VGND VPWR VPWR sky130_fd_sc_hd__diode_2
X_2124_ net112 net156 _0500_ VGND VGND VPWR VPWR _0206_ sky130_fd_sc_hd__mux2_1
X_3173_ clknet_4_2_0_clk my_divider.en_r _0084_ VGND VGND VPWR VPWR my_divider.state
+ sky130_fd_sc_hd__dfrtp_1
XTAP_TAPCELL_ROW_49_452 VGND VPWR sky130_fd_sc_hd__tapvpwrvgnd_1
XFILLER_34_173 VGND VGND VPWR VPWR sky130_fd_sc_hd__fill_2
X_2055_ net42 _1064_ _1097_ acc_reg\[7\] _1100_ VGND VGND VPWR VPWR _0457_ sky130_fd_sc_hd__a221o_1
XFILLER_25_19 VGND VGND VPWR VPWR sky130_fd_sc_hd__fill_1
XPHY_EDGE_ROW_16_Left_79 VGND VGND VPWR VPWR sky130_fd_sc_hd__decap_3
X_1839_ _1381_ _1382_ VGND VGND VPWR VPWR _1383_ sky130_fd_sc_hd__nor2_1
X_1908_ _1399_ _1402_ _1403_ VGND VGND VPWR VPWR _1452_ sky130_fd_sc_hd__o21ai_1
XFILLER_34_195 VGND VGND VPWR VPWR sky130_fd_sc_hd__fill_1
XTAP_TAPCELL_ROW_32_341 VGND VPWR sky130_fd_sc_hd__tapvpwrvgnd_1
XFILLER_22_368 VGND VGND VPWR VPWR sky130_fd_sc_hd__fill_2
X_2888_ net2 VGND VGND VPWR VPWR _0169_ sky130_fd_sc_hd__inv_2
X_2957_ net5 VGND VGND VPWR VPWR _0053_ sky130_fd_sc_hd__inv_2
XFILLER_57_276 VGND VGND VPWR VPWR sky130_fd_sc_hd__decap_3
XFILLER_31_73 VGND VGND VPWR VPWR sky130_fd_sc_hd__fill_2
XFILLER_48_243 VGND VGND VPWR VPWR sky130_fd_sc_hd__decap_3
XFILLER_48_232 VGND VGND VPWR VPWR sky130_fd_sc_hd__decap_3
XFILLER_0_272 VGND VGND VPWR VPWR sky130_fd_sc_hd__decap_3
XFILLER_48_287 VGND VGND VPWR VPWR sky130_fd_sc_hd__decap_3
XTAP_TAPCELL_ROW_46_433 VGND VPWR sky130_fd_sc_hd__tapvpwrvgnd_1
XFILLER_31_165 VGND VGND VPWR VPWR sky130_fd_sc_hd__decap_3
X_2742_ _0982_ _0983_ _0994_ VGND VGND VPWR VPWR _1014_ sky130_fd_sc_hd__nor3_1
X_2811_ net5 VGND VGND VPWR VPWR _0092_ sky130_fd_sc_hd__inv_2
XFILLER_8_361 VGND VGND VPWR VPWR sky130_fd_sc_hd__decap_3
X_1624_ _1155_ _1167_ VGND VGND VPWR VPWR _1168_ sky130_fd_sc_hd__nor2_1
X_2673_ _0958_ _0961_ _0962_ net157 _1057_ VGND VGND VPWR VPWR _0282_ sky130_fd_sc_hd__a32o_1
X_1555_ _1087_ _1095_ _1098_ VGND VGND VPWR VPWR _1100_ sky130_fd_sc_hd__or3_4
XFILLER_36_18 VGND VGND VPWR VPWR sky130_fd_sc_hd__decap_3
X_3087_ clknet_4_14_0_clk _0346_ _0183_ VGND VGND VPWR VPWR acc_reg\[8\] sky130_fd_sc_hd__dfrtp_4
X_2107_ net96 net95 net88 VGND VGND VPWR VPWR _0220_ sky130_fd_sc_hd__mux2_1
X_3156_ clknet_4_1_0_clk net203 _0067_ VGND VGND VPWR VPWR state\[4\] sky130_fd_sc_hd__dfrtp_4
XFILLER_62_290 VGND VGND VPWR VPWR sky130_fd_sc_hd__decap_3
XFILLER_54_279 VGND VGND VPWR VPWR sky130_fd_sc_hd__decap_3
XFILLER_52_17 VGND VGND VPWR VPWR sky130_fd_sc_hd__decap_3
X_2038_ _1130_ _0385_ VGND VGND VPWR VPWR _0442_ sky130_fd_sc_hd__xnor2_1
XFILLER_6_309 VGND VGND VPWR VPWR sky130_fd_sc_hd__decap_3
XFILLER_10_338 VGND VGND VPWR VPWR sky130_fd_sc_hd__decap_3
XFILLER_10_349 VGND VGND VPWR VPWR sky130_fd_sc_hd__decap_3
Xclkbuf_4_13_0_clk clknet_0_clk VGND VGND VPWR VPWR clknet_4_13_0_clk sky130_fd_sc_hd__clkbuf_8
XFILLER_7_6 VGND VGND VPWR VPWR sky130_fd_sc_hd__decap_3
XFILLER_45_257 VGND VGND VPWR VPWR sky130_fd_sc_hd__decap_3
XTAP_TAPCELL_ROW_43_414 VGND VPWR sky130_fd_sc_hd__tapvpwrvgnd_1
XFILLER_9_169 VGND VGND VPWR VPWR sky130_fd_sc_hd__decap_3
XFILLER_13_110 VGND VGND VPWR VPWR sky130_fd_sc_hd__fill_2
XFILLER_61_9 VGND VGND VPWR VPWR sky130_fd_sc_hd__decap_3
Xrebuffer6 net10 VGND VGND VPWR VPWR net11 sky130_fd_sc_hd__dlygate4sd1_1
X_3010_ clknet_4_2_0_clk net197 _0106_ VGND VGND VPWR VPWR div_quotient\[0\] sky130_fd_sc_hd__dfrtp_1
X_2725_ _0998_ _1000_ _0975_ VGND VGND VPWR VPWR _1001_ sky130_fd_sc_hd__a21o_1
X_2656_ _0800_ _0802_ _0804_ _0951_ _0954_ VGND VGND VPWR VPWR _0955_ sky130_fd_sc_hd__o311a_1
XFILLER_8_191 VGND VGND VPWR VPWR sky130_fd_sc_hd__decap_3
XFILLER_59_349 VGND VGND VPWR VPWR sky130_fd_sc_hd__decap_3
XFILLER_59_305 VGND VGND VPWR VPWR sky130_fd_sc_hd__decap_3
XFILLER_47_28 VGND VGND VPWR VPWR sky130_fd_sc_hd__decap_3
X_1607_ _1109_ _1142_ VGND VGND VPWR VPWR _1151_ sky130_fd_sc_hd__and2b_1
X_1538_ _1073_ _1070_ net278 VGND VGND VPWR VPWR _0239_ sky130_fd_sc_hd__mux2_1
X_2587_ _0856_ _0858_ VGND VGND VPWR VPWR _0886_ sky130_fd_sc_hd__or2_1
XTAP_TAPCELL_ROW_57_506 VGND VPWR sky130_fd_sc_hd__tapvpwrvgnd_1
XFILLER_42_227 VGND VGND VPWR VPWR sky130_fd_sc_hd__decap_3
XFILLER_27_279 VGND VGND VPWR VPWR sky130_fd_sc_hd__fill_1
X_3139_ clknet_4_1_0_clk net77 _0050_ VGND VGND VPWR VPWR shift_out\[12\] sky130_fd_sc_hd__dfrtp_1
XPHY_EDGE_ROW_19_Left_82 VGND VGND VPWR VPWR sky130_fd_sc_hd__decap_3
XFILLER_6_117 VGND VGND VPWR VPWR sky130_fd_sc_hd__fill_2
XFILLER_2_334 VGND VGND VPWR VPWR sky130_fd_sc_hd__fill_2
XFILLER_5_3 VGND VGND VPWR VPWR sky130_fd_sc_hd__fill_2
Xhold180 _1048_ VGND VGND VPWR VPWR net185 sky130_fd_sc_hd__dlygate4sd3_1
XFILLER_58_360 VGND VGND VPWR VPWR sky130_fd_sc_hd__decap_3
Xhold191 div_quotient\[0\] VGND VGND VPWR VPWR net196 sky130_fd_sc_hd__dlygate4sd3_1
XFILLER_33_249 VGND VGND VPWR VPWR sky130_fd_sc_hd__fill_1
XFILLER_18_279 VGND VGND VPWR VPWR sky130_fd_sc_hd__fill_1
X_2510_ _0793_ _0808_ VGND VGND VPWR VPWR _0809_ sky130_fd_sc_hd__nand2b_1
X_2372_ _1055_ net211 _0641_ _0682_ _0684_ VGND VGND VPWR VPWR _0305_ sky130_fd_sc_hd__a221o_1
XFILLER_38_3 VGND VGND VPWR VPWR sky130_fd_sc_hd__fill_1
XFILLER_5_172 VGND VGND VPWR VPWR sky130_fd_sc_hd__decap_3
X_2441_ _0736_ _0739_ VGND VGND VPWR VPWR _0740_ sky130_fd_sc_hd__nand2b_1
XTAP_TAPCELL_ROW_62_542 VGND VPWR sky130_fd_sc_hd__tapvpwrvgnd_1
X_2708_ my_divider.remainder_reg\[3\] my_divider.divisor_reg\[3\] VGND VGND VPWR VPWR
+ _0984_ sky130_fd_sc_hd__and2b_1
X_2639_ _0862_ _0881_ _0887_ VGND VGND VPWR VPWR _0938_ sky130_fd_sc_hd__o21a_1
XFILLER_59_157 VGND VGND VPWR VPWR sky130_fd_sc_hd__decap_3
XFILLER_58_38 VGND VGND VPWR VPWR sky130_fd_sc_hd__decap_3
XFILLER_58_27 VGND VGND VPWR VPWR sky130_fd_sc_hd__fill_1
XFILLER_47_319 VGND VGND VPWR VPWR sky130_fd_sc_hd__decap_3
XFILLER_30_219 VGND VGND VPWR VPWR sky130_fd_sc_hd__decap_3
XPHY_EDGE_ROW_4_Left_67 VGND VGND VPWR VPWR sky130_fd_sc_hd__decap_3
XTAP_TAPCELL_ROW_25_299 VGND VPWR sky130_fd_sc_hd__tapvpwrvgnd_1
XFILLER_61_311 VGND VGND VPWR VPWR sky130_fd_sc_hd__decap_3
XFILLER_48_60 VGND VGND VPWR VPWR sky130_fd_sc_hd__fill_2
XFILLER_0_12 VGND VGND VPWR VPWR sky130_fd_sc_hd__decap_3
XFILLER_61_355 VGND VGND VPWR VPWR sky130_fd_sc_hd__decap_3
X_1872_ _1413_ _1415_ _1229_ VGND VGND VPWR VPWR _1416_ sky130_fd_sc_hd__a21o_1
X_1941_ _1483_ _1484_ VGND VGND VPWR VPWR _1485_ sky130_fd_sc_hd__or2_1
X_2990_ clknet_4_10_0_clk net80 _0086_ VGND VGND VPWR VPWR my_divider.divisor_reg\[1\]
+ sky130_fd_sc_hd__dfrtp_1
X_2355_ _0629_ _0654_ _0670_ _0671_ VGND VGND VPWR VPWR _0672_ sky130_fd_sc_hd__a22o_1
X_2286_ _0401_ _1107_ VGND VGND VPWR VPWR _0609_ sky130_fd_sc_hd__nand2b_1
X_2424_ my_sum_sub.cm_exp\[6\] _0698_ _0702_ my_sum_sub.cm_exp\[7\] VGND VGND VPWR
+ VPWR _0723_ sky130_fd_sc_hd__a31o_1
XFILLER_49_190 VGND VGND VPWR VPWR sky130_fd_sc_hd__fill_2
XFILLER_44_29 VGND VGND VPWR VPWR sky130_fd_sc_hd__decap_3
XFILLER_62_119 VGND VGND VPWR VPWR sky130_fd_sc_hd__decap_3
XFILLER_55_160 VGND VGND VPWR VPWR sky130_fd_sc_hd__decap_3
XFILLER_47_116 VGND VGND VPWR VPWR sky130_fd_sc_hd__decap_3
XTAP_TAPCELL_ROW_38_380 VGND VPWR sky130_fd_sc_hd__tapvpwrvgnd_1
XFILLER_11_241 VGND VGND VPWR VPWR sky130_fd_sc_hd__decap_3
XFILLER_50_94 VGND VGND VPWR VPWR sky130_fd_sc_hd__decap_3
XFILLER_59_81 VGND VGND VPWR VPWR sky130_fd_sc_hd__decap_3
X_2140_ shift_in\[3\] shift_in\[2\] shift_in\[1\] VGND VGND VPWR VPWR _0501_ sky130_fd_sc_hd__or3_1
XFILLER_53_119 VGND VGND VPWR VPWR sky130_fd_sc_hd__decap_3
XFILLER_53_108 VGND VGND VPWR VPWR sky130_fd_sc_hd__decap_3
XFILLER_46_171 VGND VGND VPWR VPWR sky130_fd_sc_hd__fill_2
XFILLER_38_138 VGND VGND VPWR VPWR sky130_fd_sc_hd__fill_2
X_2071_ _0469_ _0470_ net280 VGND VGND VPWR VPWR _0471_ sky130_fd_sc_hd__o21a_1
XFILLER_61_163 VGND VGND VPWR VPWR sky130_fd_sc_hd__decap_3
X_1855_ _1393_ _1394_ VGND VGND VPWR VPWR _1399_ sky130_fd_sc_hd__nor2_1
X_1924_ _1315_ _1410_ VGND VGND VPWR VPWR _1468_ sky130_fd_sc_hd__xnor2_1
X_2973_ net5 VGND VGND VPWR VPWR _0069_ sky130_fd_sc_hd__inv_2
X_1786_ my_mul.x2\[1\] acc_reg\[5\] _1328_ VGND VGND VPWR VPWR _1330_ sky130_fd_sc_hd__and3_1
XFILLER_39_29 VGND VGND VPWR VPWR sky130_fd_sc_hd__fill_1
X_2338_ _0604_ _0650_ _0656_ _0616_ _1055_ VGND VGND VPWR VPWR _0657_ sky130_fd_sc_hd__a221o_1
X_2269_ _0593_ _0595_ _0596_ VGND VGND VPWR VPWR _0597_ sky130_fd_sc_hd__a21o_1
X_2407_ net12 _0700_ VGND VGND VPWR VPWR _0706_ sky130_fd_sc_hd__xnor2_1
XFILLER_52_141 VGND VGND VPWR VPWR sky130_fd_sc_hd__decap_3
XTAP_TAPCELL_ROW_35_361 VGND VPWR sky130_fd_sc_hd__tapvpwrvgnd_1
XFILLER_4_237 VGND VGND VPWR VPWR sky130_fd_sc_hd__decap_3
Xhold40 _0227_ VGND VGND VPWR VPWR net45 sky130_fd_sc_hd__dlygate4sd3_1
XFILLER_45_50 VGND VGND VPWR VPWR sky130_fd_sc_hd__decap_3
Xhold62 _0232_ VGND VGND VPWR VPWR net67 sky130_fd_sc_hd__dlygate4sd3_1
XFILLER_28_171 VGND VGND VPWR VPWR sky130_fd_sc_hd__decap_3
Xhold51 shift_out\[10\] VGND VGND VPWR VPWR net56 sky130_fd_sc_hd__dlygate4sd3_1
Xhold95 my_mul.x2\[14\] VGND VGND VPWR VPWR net100 sky130_fd_sc_hd__dlygate4sd3_1
Xhold84 div_quotient\[3\] VGND VGND VPWR VPWR net89 sky130_fd_sc_hd__dlygate4sd3_1
Xhold73 my_sum_sub.result\[4\] VGND VGND VPWR VPWR net78 sky130_fd_sc_hd__dlygate4sd3_1
XFILLER_31_369 VGND VGND VPWR VPWR sky130_fd_sc_hd__fill_1
XPHY_EDGE_ROW_7_Left_70 VGND VGND VPWR VPWR sky130_fd_sc_hd__decap_3
X_1640_ _1165_ _1170_ _1180_ VGND VGND VPWR VPWR _1184_ sky130_fd_sc_hd__a21oi_1
XANTENNA_4 my_mul.x2\[5\] VGND VGND VPWR VPWR sky130_fd_sc_hd__diode_2
X_1571_ my_mul.x2\[11\] acc_reg\[11\] _1112_ VGND VGND VPWR VPWR _1115_ sky130_fd_sc_hd__and3_1
XFILLER_3_281 VGND VGND VPWR VPWR sky130_fd_sc_hd__decap_3
XTAP_TAPCELL_ROW_49_453 VGND VPWR sky130_fd_sc_hd__tapvpwrvgnd_1
XFILLER_26_108 VGND VGND VPWR VPWR sky130_fd_sc_hd__fill_2
Xrebuffer16 my_sum_sub.cm_exp\[1\] VGND VGND VPWR VPWR net21 sky130_fd_sc_hd__buf_2
X_2123_ _0500_ VGND VGND VPWR VPWR _0004_ sky130_fd_sc_hd__inv_2
X_3172_ clknet_4_0_0_clk net27 _0083_ VGND VGND VPWR VPWR my_mul.reg1en.q\[0\] sky130_fd_sc_hd__dfrtp_1
XFILLER_20_3 VGND VGND VPWR VPWR sky130_fd_sc_hd__fill_2
X_2054_ net193 _1091_ _0453_ _0455_ state\[4\] VGND VGND VPWR VPWR _0456_ sky130_fd_sc_hd__o221a_1
XFILLER_34_141 VGND VGND VPWR VPWR sky130_fd_sc_hd__decap_3
XFILLER_22_336 VGND VGND VPWR VPWR sky130_fd_sc_hd__decap_3
X_1838_ my_mul.x2\[1\] my_mul.x2\[0\] acc_reg\[3\] acc_reg\[2\] VGND VGND VPWR VPWR
+ _1382_ sky130_fd_sc_hd__and4_1
X_1907_ _1448_ _1450_ _1423_ VGND VGND VPWR VPWR _1451_ sky130_fd_sc_hd__mux2_1
XTAP_TAPCELL_ROW_32_342 VGND VPWR sky130_fd_sc_hd__tapvpwrvgnd_1
X_2887_ net2 VGND VGND VPWR VPWR _0168_ sky130_fd_sc_hd__inv_2
X_2956_ net5 VGND VGND VPWR VPWR _0052_ sky130_fd_sc_hd__inv_2
X_1769_ _1312_ _1287_ VGND VGND VPWR VPWR _1313_ sky130_fd_sc_hd__and2b_1
XFILLER_57_299 VGND VGND VPWR VPWR sky130_fd_sc_hd__decap_3
XFILLER_57_255 VGND VGND VPWR VPWR sky130_fd_sc_hd__fill_1
XFILLER_40_111 VGND VGND VPWR VPWR sky130_fd_sc_hd__fill_2
XFILLER_25_196 VGND VGND VPWR VPWR sky130_fd_sc_hd__decap_3
XFILLER_25_163 VGND VGND VPWR VPWR sky130_fd_sc_hd__decap_3
XFILLER_9_307 VGND VGND VPWR VPWR sky130_fd_sc_hd__decap_3
XFILLER_13_303 VGND VGND VPWR VPWR sky130_fd_sc_hd__decap_3
XFILLER_13_369 VGND VGND VPWR VPWR sky130_fd_sc_hd__fill_1
XPHY_EDGE_ROW_33_Left_96 VGND VGND VPWR VPWR sky130_fd_sc_hd__decap_3
XFILLER_48_211 VGND VGND VPWR VPWR sky130_fd_sc_hd__fill_2
XFILLER_0_284 VGND VGND VPWR VPWR sky130_fd_sc_hd__decap_3
XFILLER_0_240 VGND VGND VPWR VPWR sky130_fd_sc_hd__decap_3
XTAP_TAPCELL_ROW_46_434 VGND VPWR sky130_fd_sc_hd__tapvpwrvgnd_1
XFILLER_31_177 VGND VGND VPWR VPWR sky130_fd_sc_hd__decap_3
X_2810_ net5 VGND VGND VPWR VPWR _0091_ sky130_fd_sc_hd__inv_2
X_2741_ _0630_ _0973_ _1013_ VGND VGND VPWR VPWR _0266_ sky130_fd_sc_hd__a21o_1
X_2672_ _0854_ _0949_ _0903_ VGND VGND VPWR VPWR _0962_ sky130_fd_sc_hd__a21oi_1
X_1623_ _1154_ _1166_ _1165_ VGND VGND VPWR VPWR _1167_ sky130_fd_sc_hd__o21ai_1
X_1554_ _1087_ _1095_ _1098_ VGND VGND VPWR VPWR _1099_ sky130_fd_sc_hd__nor3_4
.ends
